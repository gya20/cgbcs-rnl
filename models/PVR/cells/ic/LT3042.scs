simulator lang=spectre
// @RNL(type="header") { @VERSION("0.3"); @USE-PACKAGE(name="cgbcs-pvr", version="1.0", path="../../symbols.rnl") }

subckt L3_TM_PVR_LT3042 (set out bias g)
parameters ereg=2.53n freg=1M rreg=50m vos=0
Xn (u set g) L4_TM_COMMON_NOISE ew=ereg
Ecmd (v g u g) vcvs gain=1
Eoff (w v bias g) vcvs gain=vos
Rf (w x) resistor r=1k isnoisy=no
Cf (x g) capacitor c=1/(6.283185307*1k*freg)
Edrive (b g x g) vcvs gain=1
Rreg (b out) resistor r=rreg isnoisy=no
// @RNL {
//   #Xn @PLACE(48, 0);
//   #Ecmd @PLACE(62, 0);
//   (64.4, 1.4) @TEXT("Ecmd  1", size=0.76, halign="start");
//   #Eoff @PLACE(77, 0);
//   (79.4, 1.4) @TEXT("Eoff  vos", size=0.76, halign="start");
//   #Rf @PLACE(90, 4);
//   (90, 5.45) @TEXT("Rf  1k", size=0.76, halign="middle");
//   #Cf @PLACE(100, -4) => @ORIENT("R270");
//   (101.5, -4) @TEXT("Cf  C(eq)", size=0.76, halign="start");
//   #Edrive @PLACE(117, 0);
//   (119.4, 1.4) @TEXT("Edrive  1", size=0.76, halign="start");
//   #Rreg @PLACE(131, 4);
//   (131, 5.45) @TEXT("Rreg  rreg", size=0.76, halign="middle");
//   %io_set = $IO_PORT @ATTACH &set => @PLACE(37, 0) => @ORIENT("R0");
//   &set @WIRE(mode="straight") {%io_set:p #Xn:2};
//   %io_out = $IO_PORT @ATTACH &out => @PLACE(140, 4) => @ORIENT("R180");
//   &out @WIRE(mode="straight") {%io_out:p #Rreg:2};
//   %io_bias = $IO_PORT @ATTACH &bias => @PLACE(67, 1) => @ORIENT("R0");
//   &bias @WIRE(mode="straight") {%io_bias:p #Eoff:3};
//   %io_g = $IO_PORT @ATTACH &g => @PLACE(48, -10) => @ORIENT("R90");
//   &g @WIRE(mode="straight") {%io_g:p #Xn:3};
//   &u @WIRE(mode="straight") {#Xn:1 (56, 0) (56, 1) #Ecmd:3};
//   &v @WIRE(mode="straight") {#Ecmd:1 (62, 5) (72, 5) (72, -5) (77, -5) #Eoff:2};
//   &w @WIRE(mode="straight") {#Eoff:1 (77, 5) (85, 5) (85, 4) #Rf:1};
//   &b @WIRE(mode="straight") {#Edrive:1 (117, 5) (126, 5) (126, 4) #Rreg:1};
//   &x @WIRE(mode="straight") {#Rf:2 (100, 4) #Cf:1};
//   &x @WIRE(mode="straight") {#Cf:1 (100, 1) #Edrive:3};
//   %ground0 = $GROUND @ATTACH &g => @PLACE(62, -5);
//   &g @WIRE(mode="straight") {#Ecmd:2 %ground0:p};
//   %ground1 = $GROUND @ATTACH &g => @PLACE(56, -1);
//   &g @WIRE(mode="straight") {#Ecmd:4 %ground1:p};
//   %ground2 = $GROUND @ATTACH &g => @PLACE(71, -1);
//   &g @WIRE(mode="straight") {#Eoff:4 %ground2:p};
//   %ground3 = $GROUND @ATTACH &g => @PLACE(100, -9);
//   &g @WIRE(mode="straight") {#Cf:2 %ground3:p};
//   %ground4 = $GROUND @ATTACH &g => @PLACE(117, -5);
//   &g @WIRE(mode="straight") {#Edrive:2 %ground4:p};
//   %ground5 = $GROUND @ATTACH &g => @PLACE(111, -1);
//   &g @WIRE(mode="straight") {#Edrive:4 %ground5:p}
// }
ends L3_TM_PVR_LT3042
