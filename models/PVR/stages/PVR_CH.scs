simulator lang=spectre
// @RNL(type="header") { @VERSION("0.3"); @USE-PACKAGE(name="cgbcs-pvr", version="1.0", path="../symbols.rnl") }
subckt L1_TM_PVR_PVR_CH (cmd bias buf card pad die g)
parameters ecmd=0 ccard=100u cpad=11.1u ratiosq=18.29 lenmm=27.5 cum=35 rreturn=5m lmm=0.5n cmm=0.12p rcontact=10m lcontact=1n rneck=2m lneck=1n lcap=0.7n esr=10m
Xcard (cmd bias buf card plug g) L2_TM_PVR_CARD_CHANNEL ecmd=ecmd ccard=ccard ratiosq=ratiosq lenmm=lenmm cum=cum rreturn=rreturn lmm=lmm cmm=cmm rcontact=rcontact lcontact=lcontact rneck=rneck lneck=lneck lcap=lcap esr=esr
Xport (plug pad die g) L2_TM_PVR_CARD_PATH cpad=cpad
// @RNL {
//   #Xcard @PLACE(0, 0);
//   #Xport @PLACE(35, 0);
//   %io_cmd = $IO_PORT @ATTACH &cmd => @PLACE(-21, 0) => @ORIENT("R0");
//   &cmd @WIRE(mode="straight") {%io_cmd:p #Xcard:1};
//   %io_bias = $IO_PORT @ATTACH &bias => @PLACE(-5, -14) => @ORIENT("R90");
//   &bias @WIRE(mode="straight") {%io_bias:p #Xcard:2};
//   %io_buf = $IO_PORT @ATTACH &buf => @PLACE(21, 4) => @ORIENT("R180");
//   &buf @WIRE(mode="straight") {%io_buf:p #Xcard:3};
//   %io_card = $IO_PORT @ATTACH &card => @PLACE(21, 0) => @ORIENT("R180");
//   &card @WIRE(mode="straight") {%io_card:p #Xcard:4};
//   %io_pad = $IO_PORT @ATTACH &pad => @PLACE(49, 2) => @ORIENT("R180");
//   &pad @WIRE(mode="straight") {%io_pad:p #Xport:2};
//   %io_die = $IO_PORT @ATTACH &die => @PLACE(49, -2) => @ORIENT("R180");
//   &die @WIRE(mode="straight") {%io_die:p #Xport:3};
//   %io_g = $IO_PORT @ATTACH &g => @PLACE(5, -14) => @ORIENT("R90");
//   &g @WIRE(mode="straight") {%io_g:p #Xcard:6};
//   &plug @WIRE(mode="straight") {#Xcard:5 (25, -4) (25, 0) #Xport:1};
//   %ground0 = $GROUND @ATTACH &g => @PLACE(35, -7);
//   &g @WIRE(mode="straight") {#Xport:4 %ground0:p}
// }
ends L1_TM_PVR_PVR_CH
