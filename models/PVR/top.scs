simulator lang=spectre
// @RNL(type="header") { @VERSION("0.3"); @USE-PACKAGE(name="cgbcs-pvr", version="1.0", path="symbols.rnl") }
include "cells/basic/NOISE.scs"
include "cells/ic/LTC2972_SET.scs"
include "stages/input/PVR_SET.scs"
include "cells/ic/LT3042.scs"
include "cells/basic/LINE.scs"
include "cells/basic/PI_SECTION.scs"
include "stages/output/CARD_PCB.scs"
include "stages/CARD_CHANNEL.scs"
include "stages/output/CARD_PATH.scs"
include "stages/PVR_CH.scs"
include "stages/CARD_ONLY.scs"

subckt TM_PVR_PVR (cmd1 cmd2 bias buf1 card1 pad1 die1 buf2 card2 pad2 die2 g)
parameters ccard=100u len1=27.5 len2=44.37 sq1=18.29 sq2=29.11 cum=35 rreturn=5m lmm=0.5n cmm=0.12p rcontact=10m lcontact=1n rneck=2m lneck=1n lcap=0.7n esr=10m ecmd=0 cpad=11.1u
Xch1 (cmd1 bias buf1 card1 pad1 die1 g) TM_PVR_PVR_CH ecmd=ecmd ccard=ccard lenmm=len1 ratiosq=sq1 cum=cum rreturn=rreturn lmm=lmm cmm=cmm rcontact=rcontact lcontact=lcontact rneck=rneck lneck=lneck lcap=lcap esr=esr cpad=cpad
Xch2 (cmd2 bias buf2 card2 pad2 die2 g) TM_PVR_PVR_CH ecmd=ecmd ccard=ccard lenmm=len2 ratiosq=sq2 cum=cum rreturn=rreturn lmm=lmm cmm=cmm rcontact=rcontact lcontact=lcontact rneck=rneck lneck=lneck lcap=lcap esr=esr cpad=cpad
// @RNL {
//   #Xch1 @PLACE(0, 11);
//   #Xch2 @PLACE(0, -11);
//   %io_cmd1 = $IO_PORT @ATTACH &cmd1 => @PLACE(-16, 11) => @ORIENT("R0");
//   &cmd1 @WIRE(mode="straight") {%io_cmd1:p #Xch1:1};
//   %io_cmd2 = $IO_PORT @ATTACH &cmd2 => @PLACE(-16, -11) => @ORIENT("R0");
//   &cmd2 @WIRE(mode="straight") {%io_cmd2:p #Xch2:1};
//   %io_bias = $IO_PORT @ATTACH &bias => @PLACE(-3, -1) => @ORIENT("R90");
//   &bias @WIRE(mode="straight") {%io_bias:p #Xch1:2};
//   %io_buf1 = $IO_PORT @ATTACH &buf1 => @PLACE(16, 14) => @ORIENT("R180");
//   &buf1 @WIRE(mode="straight") {%io_buf1:p #Xch1:3};
//   %io_card1 = $IO_PORT @ATTACH &card1 => @PLACE(16, 12) => @ORIENT("R180");
//   &card1 @WIRE(mode="straight") {%io_card1:p #Xch1:4};
//   %io_pad1 = $IO_PORT @ATTACH &pad1 => @PLACE(16, 10) => @ORIENT("R180");
//   &pad1 @WIRE(mode="straight") {%io_pad1:p #Xch1:5};
//   %io_die1 = $IO_PORT @ATTACH &die1 => @PLACE(16, 8) => @ORIENT("R180");
//   &die1 @WIRE(mode="straight") {%io_die1:p #Xch1:6};
//   %io_buf2 = $IO_PORT @ATTACH &buf2 => @PLACE(16, -8) => @ORIENT("R180");
//   &buf2 @WIRE(mode="straight") {%io_buf2:p #Xch2:3};
//   %io_card2 = $IO_PORT @ATTACH &card2 => @PLACE(16, -10) => @ORIENT("R180");
//   &card2 @WIRE(mode="straight") {%io_card2:p #Xch2:4};
//   %io_pad2 = $IO_PORT @ATTACH &pad2 => @PLACE(16, -12) => @ORIENT("R180");
//   &pad2 @WIRE(mode="straight") {%io_pad2:p #Xch2:5};
//   %io_die2 = $IO_PORT @ATTACH &die2 => @PLACE(16, -14) => @ORIENT("R180");
//   &die2 @WIRE(mode="straight") {%io_die2:p #Xch2:6};
//   %io_g = $IO_PORT @ATTACH &g => @PLACE(3, -1) => @ORIENT("R90");
//   &g @WIRE(mode="straight") {%io_g:p #Xch1:7};
//   &bias @WIRE(mode="straight") {#Xch2:2 (-3, -19)};
//   (-3, -20) @TEXT("bias", size=0.7, halign="middle", valign="middle");
//   %ground0 = $GROUND @ATTACH &g => @PLACE(3, -19);
//   &g @WIRE(mode="straight") {#Xch2:7 %ground0:p}
// }
ends TM_PVR_PVR
