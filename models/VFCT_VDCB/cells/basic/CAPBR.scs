simulator lang=spectre
// @RNL(type="header") { @VERSION("0.3"); @USE-PACKAGE(name="cgbcs-vfct-vdcb", version="1.0", path="../../symbols.rnl") }
subckt TM_LDO_CAPBR (p g)
parameters rr=10m ll=0.5n cc=22u
Xesl (p t g) TM_LDO_LINE rs=rr le=ll
Cstore (t g) capacitor c=cc
// @RNL {
//   #Xesl @PLACE(0, 0);
//   #Cstore @PLACE(35, 0);
//   (35, -3.7) @TEXT("c=cc", size=0.68, halign="middle");
//   %io_p = $IO_PORT @ATTACH &p => @PLACE(-16, 0) => @ORIENT("R0");
//   &p @WIRE(mode="straight") {%io_p:p #Xesl:1};
//   %io_g = $IO_PORT @ATTACH &g => @PLACE(0, -11) => @ORIENT("R90");
//   &g @WIRE(mode="straight") {%io_g:p #Xesl:3};
//   &t @WIRE(mode="straight") {#Xesl:2 #Cstore:1};
//   %ground0 = $GROUND @ATTACH &g => @PLACE(40, 0);
//   &g @WIRE(mode="straight") {#Cstore:2 %ground0:p}
// }
ends TM_LDO_CAPBR
