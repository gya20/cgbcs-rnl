simulator lang=spectre
// @RNL(type="header") { @VERSION("0.3"); @USE-PACKAGE(name="cgbcs-vfct-vdcb", version="1.0", path="../../symbols.rnl") }

subckt L2_TM_LDO_LT3042 (vin set out bias g)
parameters ereg=2.53n freg=1M rreg=50m vos=0 iset=100u kline=0
Gset (g set bias g) vccs gm=iset
Evnom (vbase g bias g) vcvs gain=3.3
Eline (sl set vin vbase) vcvs gain=kline
Xn (u sl g) L4_TM_COMMON_NOISE ew=ereg
Ecmd (v g u g) vcvs gain=1
Eoff (w v bias g) vcvs gain=vos
Rf (w x) resistor r=1k isnoisy=no
Cf (x g) capacitor c=1/(6.283185307*1k*freg)
Edrive (b g x g) vcvs gain=1
Rreg (b out) resistor r=rreg isnoisy=no
// @RNL {
//   #Gset @PLACE(0, 17);
//   (2.4, 18.4) @TEXT("Gset  iset", size=0.76, halign="start");
//   #Evnom @PLACE(16, 17);
//   (18.4, 18.4) @TEXT("Evnom  3.3", size=0.76, halign="start");
//   #Eline @PLACE(33, 17);
//   (35.4, 18.4) @TEXT("Eline  kline", size=0.76, halign="start");
//   #Xn @PLACE(48, 0);
//   #Ecmd @PLACE(62, 0);
//   (64.4, 1.4) @TEXT("Ecmd  1", size=0.76, halign="start");
//   #Eoff @PLACE(77, 0);
//   (79.4, 1.4) @TEXT("Eoff  vos", size=0.76, halign="start");
//   #Rf @PLACE(90, 4);
//   (90, 5.45) @TEXT("Rf  1k", size=0.76, halign="middle");
//   #Cf @PLACE(100, -4) => @ORIENT("R270");
//   (101.5, -4) @TEXT("Cf  C(eq)", size=0.76, halign="start");
//   #Edrive @PLACE(117, 0);
//   (119.4, 1.4) @TEXT("Edrive  1", size=0.76, halign="start");
//   #Rreg @PLACE(131, 4);
//   (131, 5.45) @TEXT("Rreg  rreg", size=0.76, halign="middle");
//   %io_vin = $IO_PORT @ATTACH &vin => @PLACE(23, 18) => @ORIENT("R0");
//   &vin @WIRE(mode="straight") {%io_vin:p #Eline:3};
//   %io_set = $IO_PORT @ATTACH &set => @PLACE(0, 8) => @ORIENT("R90");
//   &set @WIRE(mode="straight") {%io_set:p #Gset:2};
//   %io_out = $IO_PORT @ATTACH &out => @PLACE(140, 4) => @ORIENT("R180");
//   &out @WIRE(mode="straight") {%io_out:p #Rreg:2};
//   %io_bias = $IO_PORT @ATTACH &bias => @PLACE(-10, 18) => @ORIENT("R0");
//   &bias @WIRE(mode="straight") {%io_bias:p #Gset:3};
//   %io_g = $IO_PORT @ATTACH &g => @PLACE(0, 26) => @ORIENT("R270");
//   &g @WIRE(mode="straight") {%io_g:p #Gset:1};
//   &set @WIRE(mode="straight") {#Gset:2 (0, 12) (33, 12) #Eline:2};
//   &vbase @WIRE(mode="straight") {#Evnom:1 (16, 22) (22, 22) (22, 16) #Eline:4};
//   &sl @WIRE(mode="straight") {#Eline:1 (33, 22) (41, 22) (41, 0) #Xn:2};
//   &u @WIRE(mode="straight") {#Xn:1 (56, 0) (56, 1) #Ecmd:3};
//   &v @WIRE(mode="straight") {#Ecmd:1 (62, 5) (72, 5) (72, -5) (77, -5) #Eoff:2};
//   &w @WIRE(mode="straight") {#Eoff:1 (77, 5) (85, 5) (85, 4) #Rf:1};
//   &b @WIRE(mode="straight") {#Edrive:1 (117, 5) (126, 5) (126, 4) #Rreg:1};
//   &x @WIRE(mode="straight") {#Rf:2 (100, 4) #Cf:1};
//   &x @WIRE(mode="straight") {#Cf:1 (100, 1) #Edrive:3};
//   &bias @WIRE(mode="straight") {#Evnom:3 (10, 18)};
//   (8.8, 18) @TEXT("bias", size=0.7, halign="middle", valign="middle");
//   &bias @WIRE(mode="straight") {#Eoff:3 (71, 1)};
//   (69.8, 1) @TEXT("bias", size=0.7, halign="middle", valign="middle");
//   %ground0 = $GROUND @ATTACH &g => @PLACE(-6, 16);
//   &g @WIRE(mode="straight") {#Gset:4 %ground0:p};
//   %ground1 = $GROUND @ATTACH &g => @PLACE(16, 12);
//   &g @WIRE(mode="straight") {#Evnom:2 %ground1:p};
//   %ground2 = $GROUND @ATTACH &g => @PLACE(10, 16);
//   &g @WIRE(mode="straight") {#Evnom:4 %ground2:p};
//   %ground3 = $GROUND @ATTACH &g => @PLACE(48, -6);
//   &g @WIRE(mode="straight") {#Xn:3 %ground3:p};
//   %ground4 = $GROUND @ATTACH &g => @PLACE(62, -5);
//   &g @WIRE(mode="straight") {#Ecmd:2 %ground4:p};
//   %ground5 = $GROUND @ATTACH &g => @PLACE(56, -1);
//   &g @WIRE(mode="straight") {#Ecmd:4 %ground5:p};
//   %ground6 = $GROUND @ATTACH &g => @PLACE(71, -1);
//   &g @WIRE(mode="straight") {#Eoff:4 %ground6:p};
//   %ground7 = $GROUND @ATTACH &g => @PLACE(100, -9);
//   &g @WIRE(mode="straight") {#Cf:2 %ground7:p};
//   %ground8 = $GROUND @ATTACH &g => @PLACE(117, -5);
//   &g @WIRE(mode="straight") {#Edrive:2 %ground8:p};
//   %ground9 = $GROUND @ATTACH &g => @PLACE(111, -1);
//   &g @WIRE(mode="straight") {#Edrive:4 %ground9:p}
// }
ends L2_TM_LDO_LT3042
