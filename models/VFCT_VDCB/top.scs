simulator lang=spectre
// @RNL(type="header") { @VERSION("0.3"); @USE-PACKAGE(name="cgbcs-vfct-vdcb", version="1.0", path="symbols.rnl") }
include "Shared/RES.scs"
include "Shared/CAP.scs"
include "Shared/NOISE.scs"
include "cells/ic/LT3042.scs"
include "Shared/LINE.scs"
include "stages/LDO_CH.scs"

subckt L0_TM_LDO_LDO (vin bias outcb padcb diecb outfct padfct diefct g)
parameters rcb=20k rfct=21k rtrim=1k
Xcb (vin bias outcb padcb diecb g g) L1_TM_LDO_LDO_CH rt=rcb
Xfct (vin bias outfct padfct diefct g trim) L1_TM_LDO_LDO_CH rt=rfct-rtrim
Rtrim (trim g) L5_TM_COMMON_RES r=rtrim
// @RNL {
//   #Xcb @PLACE(0, 19);
//   #Xfct @PLACE(0, -19);
//   #Rtrim @PLACE(12, -38) => @ORIENT("R270");
//   (13.5, -38) @TEXT("Rtrim  rtrim", size=0.76, halign="start");
//   (0, 31) @TEXT("VDCB  /  2.0 V", size=1.24, halign="middle", valign="middle");
//   (0, -7) @TEXT("VFCT  /  2.1 V", size=1.24, halign="middle", valign="middle");
//   %j1 = (-20, 0);
//   $JUNCTION @ATTACH %j1;
//   %port_vin = $IO_PORT @ATTACH &vin => @PLACE(-26,0.0) => @ORIENT("R0");
//   &vin @WIRE(mode="straight") {%port_vin:p %j1};
//   &vin @WIRE(mode="straight") {%j1 (-20, 19) #Xcb:1};
//   &vin @WIRE(mode="straight") {%j1 (-20, -19) #Xfct:1};
//   %port_bias = $IO_PORT @ATTACH &bias => @PLACE(-10,9) => @ORIENT("R0");
//   &bias @WIRE(mode="straight") {%port_bias:p (-5, 9) #Xcb:2};
//   &bias @WIRE(mode="straight") {#Xfct:2 (-5, -29)};
//   (-3, -29) @TEXT("bias", size=0.84, halign="middle", valign="middle");
//   %port_outcb = $IO_PORT @ATTACH &outcb => @PLACE(22,23) => @ORIENT("R180");
//   &outcb @WIRE(mode="straight") {%port_outcb:p #Xcb:3};
//   %port_padcb = $IO_PORT @ATTACH &padcb => @PLACE(22,19) => @ORIENT("R180");
//   &padcb @WIRE(mode="straight") {%port_padcb:p #Xcb:4};
//   %port_diecb = $IO_PORT @ATTACH &diecb => @PLACE(22,15) => @ORIENT("R180");
//   &diecb @WIRE(mode="straight") {%port_diecb:p #Xcb:5};
//   %j2 = (5, 9);
//   $JUNCTION @ATTACH %j2;
//   %port_g = $IO_PORT @ATTACH &g => @PLACE(11,9) => @ORIENT("R180");
//   &g @WIRE(mode="straight") {#Xcb:6 %j2 %port_g:p};
//   %return = $GROUND @ATTACH &g => @PLACE(5,7);
//   &g @WIRE(mode="straight") {%j2 %return:p};
//   %ground3 = $GROUND @ATTACH &g => @PLACE(12,9);
//   &g @WIRE(mode="straight") {#Xcb:7 %ground3:p};
//   %ground4 = $GROUND @ATTACH &g => @PLACE(5,-29);
//   &g @WIRE(mode="straight") {#Xfct:6 %ground4:p};
//   %ground5 = $GROUND @ATTACH &g => @PLACE(12,-43);
//   &g @WIRE(mode="straight") {#Rtrim:2 %ground5:p};
//   %port_outfct = $IO_PORT @ATTACH &outfct => @PLACE(22,-15) => @ORIENT("R180");
//   &outfct @WIRE(mode="straight") {%port_outfct:p #Xfct:3};
//   %port_padfct = $IO_PORT @ATTACH &padfct => @PLACE(22,-19) => @ORIENT("R180");
//   &padfct @WIRE(mode="straight") {%port_padfct:p #Xfct:4};
//   %port_diefct = $IO_PORT @ATTACH &diefct => @PLACE(22,-23) => @ORIENT("R180");
//   &diefct @WIRE(mode="straight") {%port_diefct:p #Xfct:5};
//   &trim @WIRE(mode="straight") {#Xfct:7 #Rtrim:1}
// }
ends L0_TM_LDO_LDO
