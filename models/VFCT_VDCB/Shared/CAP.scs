simulator lang=spectre
// @RNL(type="header") { @VERSION("0.3"); @USE-PACKAGE(name="cgbcs-vfct-vdcb", version="1.0", path="../symbols.rnl") }

subckt L5_TM_COMMON_CAP (a b)
parameters c=100n kc=1 np=1 esr=30m esl=0.25n rleak=1T daf=0 rda=10M
Resr (a t) resistor r=esr/np
Gs (b h t store) vccs gm=0.1
Cx (h b) capacitor c=esl*0.01/np
Rx (h b) resistor r=1T isnoisy=no
Gi (t store h b) vccs gm=0.1
Cstore (store b) capacitor c=c*kc*np
Rleak (store b) resistor r=rleak/np
Rda (store da) resistor r=rda/np
Cda (da b) capacitor c=c*kc*np*daf
// @RNL {
//   #Resr @PLACE(0, 4);
//   (0, 5.45) @TEXT("Resr  esr/np", size=0.76, halign="middle");
//   #Gs @PLACE(0, -20) => @ORIENT("MX");
//   (2.4, -18.6) @TEXT("Gs  0.1", size=0.76, halign="start");
//   #Cx @PLACE(13, -20) => @ORIENT("R270");
//   (14.5, -20) @TEXT("Cx  esl*0.01/np", size=0.76, halign="start");
//   #Rx @PLACE(26, -20) => @ORIENT("R270");
//   (27.5, -20) @TEXT("Rx  1T", size=0.76, halign="start");
//   #Gi @PLACE(22, 4) => @ORIENT("R90");
//   (24.4, 5.4) @TEXT("Gi  0.1", size=0.76, halign="start");
//   #Cstore @PLACE(52, 4);
//   (52, 5.45) @TEXT("Cstore  c*kc*np", size=0.76, halign="middle");
//   #Rleak @PLACE(52, 14);
//   (52, 15.45) @TEXT("Rleak  rleak/np", size=0.76, halign="middle");
//   #Rda @PLACE(45, 24);
//   (45, 25.45) @TEXT("Rda  rda/np", size=0.76, halign="middle");
//   #Cda @PLACE(60, 24);
//   (60, 25.45) @TEXT("Cda  c*kc*np*daf", size=0.76, halign="middle");
//   %port_a = $IO_PORT @ATTACH &a => @PLACE(-16,4) => @ORIENT("R0");
//   &a @WIRE(mode="straight") {%port_a:p (-9, 4) #Resr:1};
//   &t @WIRE(mode="straight") {#Resr:2 #Gi:1};
//   (11, 5) @TEXT("t", size=0.85, halign="middle", valign="middle");
//   %j1 = (37, 4);
//   $JUNCTION @ATTACH %j1;
//   %j2 = (70, 4);
//   $JUNCTION @ATTACH %j2;
//   &store @WIRE(mode="straight") {#Gi:2 %j1 #Cstore:1};
//   %port_b = $IO_PORT @ATTACH &b => @PLACE(78,4) => @ORIENT("R180");
//   &b @WIRE(mode="straight") {#Cstore:2 %j2 %port_b:p};
//   %j3 = (37, 14);
//   $JUNCTION @ATTACH %j3;
//   %j4 = (70, 14);
//   $JUNCTION @ATTACH %j4;
//   &store @WIRE(mode="straight") {%j1 %j3 #Rleak:1};
//   &b @WIRE(mode="straight") {#Rleak:2 %j4 %j2};
//   &store @WIRE(mode="straight") {%j3 (37, 24) #Rda:1};
//   &da @WIRE(mode="straight") {#Rda:2 #Cda:1};
//   &b @WIRE(mode="straight") {#Cda:2 (70, 24) %j4};
//   (33, 5) @TEXT("store", size=0.9, halign="middle", valign="middle");
//   &t @WIRE(mode="straight") {#Gs:3 (-10, -21)};
//   (-12, -21) @TEXT("t", size=0.96, halign="middle", valign="middle");
//   &store @WIRE(mode="straight") {#Gs:4 (-10, -19)};
//   (-12, -19) @TEXT("store", size=0.96, halign="middle", valign="middle");
//   &h @WIRE(mode="straight") {#Gi:3 (21, -3) (18, -3)};
//   (17, -3) @TEXT("h", size=0.96, halign="middle", valign="middle");
//   &b @WIRE(mode="straight") {#Gi:4 (23, -1) (26, -1)};
//   (27, -1) @TEXT("b", size=0.96, halign="middle", valign="middle");
//   %j5 = (13, -13);
//   $JUNCTION @ATTACH %j5;
//   &h @WIRE(mode="straight") {#Gs:2 (0, -13) %j5 (26, -13) #Rx:1};
//   &h @WIRE(mode="straight") {%j5 #Cx:1};
//   (6, -12) @TEXT("h", size=0.96, halign="middle", valign="middle");
//   %j6 = (13, -27);
//   $JUNCTION @ATTACH %j6;
//   &b @WIRE(mode="straight") {#Gs:1 (0, -27) %j6 (26, -27) #Rx:2};
//   &b @WIRE(mode="straight") {%j6 #Cx:2};
//   (6, -26) @TEXT("b", size=0.96, halign="middle", valign="middle");
//   (13, -10) @TEXT("ESL integrator", size=1.05, halign="middle", valign="middle")
// }
ends L5_TM_COMMON_CAP
