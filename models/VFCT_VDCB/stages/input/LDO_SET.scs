simulator lang=spectre
// @RNL(type="header") { @VERSION("0.3"); @USE-PACKAGE(name="cgbcs-vfct-vdcb", version="1.0", path="../../symbols.rnl") }
subckt L2_TM_LDO_LDO_SET (vin bias set localin g)
parameters rt=20k
Rin (vin localin) resistor r=1
Cin (localin g) capacitor c=22u
Chf (localin g) capacitor c=100n
Rset (set g) resistor r=rt
Cset (set g) capacitor c=4.7u
// @RNL {
//   #Rin @PLACE(0, 0);
//   (0, 1.45) @TEXT("Rin  1", size=0.76, halign="middle");
//   #Cin @PLACE(9, -7) => @ORIENT("R270");
//   (10.5, -7) @TEXT("Cin  22u", size=0.76, halign="start");
//   #Chf @PLACE(18, -7) => @ORIENT("R270");
//   (19.5, -7) @TEXT("Chf  100n", size=0.76, halign="start");
//   #Rset @PLACE(34, -7) => @ORIENT("R270");
//   (35.5, -7) @TEXT("Rset  rt", size=0.76, halign="start");
//   #Cset @PLACE(45, -7) => @ORIENT("R270");
//   (46.5, -7) @TEXT("Cset  4.7u", size=0.76, halign="start");
//   %io_vin = $IO_PORT @ATTACH &vin => @PLACE(-9, 0) => @ORIENT("R0");
//   &vin @WIRE(mode="straight") {%io_vin:p #Rin:1};
//   %io_bias = $IO_PORT @ATTACH &bias => @PLACE(-16, -25);
//   %io_set = $IO_PORT @ATTACH &set => @PLACE(34, 2) => @ORIENT("R270");
//   &set @WIRE(mode="straight") {%io_set:p #Rset:1};
//   %io_localin = $IO_PORT @ATTACH &localin => @PLACE(9, 0) => @ORIENT("R180");
//   &localin @WIRE(mode="straight") {%io_localin:p #Rin:2};
//   %io_g = $IO_PORT @ATTACH &g => @PLACE(9, -16) => @ORIENT("R90");
//   &g @WIRE(mode="straight") {%io_g:p #Cin:2};
//   &set @WIRE(mode="straight") {#Rset:1 (34, -2) (45, -2) #Cset:1};
//   &localin @WIRE(mode="straight") {#Rin:2 (9, 0) #Cin:1};
//   &localin @WIRE(mode="straight") {#Cin:1 (9, -2) (18, -2) #Chf:1};
//   %ground0 = $GROUND @ATTACH &g => @PLACE(18, -12);
//   &g @WIRE(mode="straight") {#Chf:2 %ground0:p};
//   %ground1 = $GROUND @ATTACH &g => @PLACE(34, -12);
//   &g @WIRE(mode="straight") {#Rset:2 %ground1:p};
//   %ground2 = $GROUND @ATTACH &g => @PLACE(45, -12);
//   &g @WIRE(mode="straight") {#Cset:2 %ground2:p}
// }
ends L2_TM_LDO_LDO_SET
