simulator lang=spectre
// @RNL(type="header") { @VERSION("0.3"); @USE-PACKAGE(name="cgbcs-vfct-vdcb", version="1.0", path="../../symbols.rnl") }
subckt L2_TM_LDO_LDO_PATH (out pad die g)
Xnear (out g) L3_TM_LDO_DECOUPLE
Xfeed (out pad g) L4_TM_LDO_LINE rs=20m le=1n
Xpad (pad g) L3_TM_LDO_DECOUPLE
Xbond (pad die g) L4_TM_LDO_LINE rs=50m le=2n
// @RNL {
//   #Xnear @PLACE(-14, -7);
//   #Xfeed @PLACE(4, 0);
//   #Xpad @PLACE(21, -7);
//   #Xbond @PLACE(39, 0);
//   %io_out = $IO_PORT @ATTACH &out => @PLACE(-14, 3) => @ORIENT("R270");
//   &out @WIRE(mode="straight") {%io_out:p #Xnear:1};
//   %io_pad = $IO_PORT @ATTACH &pad => @PLACE(18, 0) => @ORIENT("R180");
//   &pad @WIRE(mode="straight") {%io_pad:p #Xfeed:2};
//   %io_die = $IO_PORT @ATTACH &die => @PLACE(53, 0) => @ORIENT("R180");
//   &die @WIRE(mode="straight") {%io_die:p #Xbond:2};
//   %io_g = $IO_PORT @ATTACH &g => @PLACE(-14, -17) => @ORIENT("R90");
//   &g @WIRE(mode="straight") {%io_g:p #Xnear:2};
//   &out @WIRE(mode="straight") {#Xnear:1 (-14, -1) (-6, -1) (-6, 0) #Xfeed:1};
//   &pad @WIRE(mode="straight") {#Xfeed:2 (21, 0) #Xpad:1};
//   &pad @WIRE(mode="straight") {#Xpad:1 (21, -1) (29, -1) (29, 0) #Xbond:1};
//   %ground0 = $GROUND @ATTACH &g => @PLACE(4, -7);
//   &g @WIRE(mode="straight") {#Xfeed:3 %ground0:p};
//   %ground1 = $GROUND @ATTACH &g => @PLACE(21, -13);
//   &g @WIRE(mode="straight") {#Xpad:2 %ground1:p};
//   %ground2 = $GROUND @ATTACH &g => @PLACE(39, -7);
//   &g @WIRE(mode="straight") {#Xbond:3 %ground2:p}
// }
ends L2_TM_LDO_LDO_PATH
