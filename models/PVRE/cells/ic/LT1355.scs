simulator lang=spectre
// @RNL(type="header") { @VERSION("0.3"); @USE-PACKAGE(name="cgbcs-pvre", version="1.0", path="../../symbols.rnl") }
subckt TM_PVRE_LT1355 (p n o bias g)
parameters a0=100k fu=12M ro=10 ew=10n vos=0
Xamp (p n o bias g) TM_PVRE_AMP a0=a0 fu=fu ro=ro ew=ew vos=vos
// @RNL {
//   #Xamp @PLACE(0, 0);
//   %io_p = $IO_PORT @ATTACH &p => @PLACE(-13, -2) => @ORIENT("R0");
//   &p @WIRE(mode="straight") {%io_p:p #Xamp:1};
//   %io_n = $IO_PORT @ATTACH &n => @PLACE(-13, 2) => @ORIENT("R0");
//   &n @WIRE(mode="straight") {%io_n:p #Xamp:2};
//   %io_o = $IO_PORT @ATTACH &o => @PLACE(13, 0) => @ORIENT("R180");
//   &o @WIRE(mode="straight") {%io_o:p #Xamp:3};
//   %io_bias = $IO_PORT @ATTACH &bias => @PLACE(-2, 12) => @ORIENT("R270");
//   &bias @WIRE(mode="straight") {%io_bias:p #Xamp:4};
//   %io_g = $IO_PORT @ATTACH &g => @PLACE(-2, -12) => @ORIENT("R90");
//   &g @WIRE(mode="straight") {%io_g:p #Xamp:5}
// }
ends TM_PVRE_LT1355
