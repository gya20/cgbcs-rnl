simulator lang=spectre
// @RNL(type="header") { @VERSION("0.3"); @USE-PACKAGE(name="cgbcs-pvre", version="1.0", path="../symbols.rnl") }

subckt L0_TM_PVRE_CARD_ONLY (cmop dac1 dac2 bias buf1 card1 plug1 buf2 card2 plug2 g)
parameters ccard=100u len1=76.2 len2=82.96 sq1=42.86 sq2=46.66 cum=35 rreturn=5m lmm=0.5n cmm=0.12p rcontact=10m lcontact=1n rneck=2m lneck=1n lcap=0.7n esr=10m rin=1k edac=0 ecm=0
Xcm (cm cmop g) L4_TM_COMMON_NOISE ew=ecm
Xch1 (cm dac1 bias buf1 card1 plug1 g) L2_TM_PVRE_CARD_CHANNEL rin=rin edac=edac ccard=ccard lenmm=len1 ratiosq=sq1 cum=cum rreturn=rreturn lmm=lmm cmm=cmm rcontact=rcontact lcontact=lcontact rneck=rneck lneck=lneck lcap=lcap esr=esr
Xch2 (cm dac2 bias buf2 card2 plug2 g) L2_TM_PVRE_CARD_CHANNEL rin=rin edac=edac ccard=ccard lenmm=len2 ratiosq=sq2 cum=cum rreturn=rreturn lmm=lmm cmm=cmm rcontact=rcontact lcontact=lcontact rneck=rneck lneck=lneck lcap=lcap esr=esr
// @RNL {
//   #Xcm @PLACE(0, 0);
//   #Xch1 @PLACE(35, 19);
//   #Xch2 @PLACE(35, -19);
//   (35, 31) @TEXT("CH 1", size=1.24, halign="middle", valign="middle");
//   (35, -7) @TEXT("CH 2", size=1.24, halign="middle", valign="middle");
//   %j1 = (15, 0);
//   $JUNCTION @ATTACH %j1;
//   &cm @WIRE(mode="straight") {#Xcm:1 %j1};
//   &cm @WIRE(mode="straight") {%j1 (15, 21) #Xch1:1};
//   &cm @WIRE(mode="straight") {%j1 (15, -17) #Xch2:1};
//   %port_cmop = $IO_PORT @ATTACH &cmop => @PLACE(-12,0) => @ORIENT("R0");
//   &cmop @WIRE(mode="straight") {%port_cmop:p #Xcm:2};
//   %j2 = (0, -6);
//   $JUNCTION @ATTACH %j2;
//   %port_g = $IO_PORT @ATTACH &g => @PLACE(6,-6) => @ORIENT("R180");
//   &g @WIRE(mode="straight") {#Xcm:3 %j2 %port_g:p};
//   %return = $GROUND @ATTACH &g => @PLACE(0,-8);
//   &g @WIRE(mode="straight") {%j2 %return:p};
//   %ground3 = $GROUND @ATTACH &g => @PLACE(40,9);
//   &g @WIRE(mode="straight") {#Xch1:7 %ground3:p};
//   %ground4 = $GROUND @ATTACH &g => @PLACE(40,-29);
//   &g @WIRE(mode="straight") {#Xch2:7 %ground4:p};
//   %port_dac1 = $IO_PORT @ATTACH &dac1 => @PLACE(13,17) => @ORIENT("R0");
//   &dac1 @WIRE(mode="straight") {%port_dac1:p #Xch1:2};
//   %port_bias = $IO_PORT @ATTACH &bias => @PLACE(25,9) => @ORIENT("R0");
//   &bias @WIRE(mode="straight") {%port_bias:p (30, 9) #Xch1:3};
//   &bias @WIRE(mode="straight") {#Xch2:3 (30, -29)};
//   (32, -29) @TEXT("bias", size=0.84, halign="middle", valign="middle");
//   %port_buf1 = $IO_PORT @ATTACH &buf1 => @PLACE(57,23) => @ORIENT("R180");
//   &buf1 @WIRE(mode="straight") {%port_buf1:p #Xch1:4};
//   %port_card1 = $IO_PORT @ATTACH &card1 => @PLACE(57,19) => @ORIENT("R180");
//   &card1 @WIRE(mode="straight") {%port_card1:p #Xch1:5};
//   %port_plug1 = $IO_PORT @ATTACH &plug1 => @PLACE(57,15) => @ORIENT("R180");
//   &plug1 @WIRE(mode="straight") {%port_plug1:p #Xch1:6};
//   %port_dac2 = $IO_PORT @ATTACH &dac2 => @PLACE(13,-21) => @ORIENT("R0");
//   &dac2 @WIRE(mode="straight") {%port_dac2:p #Xch2:2};
//   %port_buf2 = $IO_PORT @ATTACH &buf2 => @PLACE(57,-15) => @ORIENT("R180");
//   &buf2 @WIRE(mode="straight") {%port_buf2:p #Xch2:4};
//   %port_card2 = $IO_PORT @ATTACH &card2 => @PLACE(57,-19) => @ORIENT("R180");
//   &card2 @WIRE(mode="straight") {%port_card2:p #Xch2:5};
//   %port_plug2 = $IO_PORT @ATTACH &plug2 => @PLACE(57,-23) => @ORIENT("R180");
//   &plug2 @WIRE(mode="straight") {%port_plug2:p #Xch2:6}
// }
ends L0_TM_PVRE_CARD_ONLY
