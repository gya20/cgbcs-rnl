simulator lang=spectre
// @RNL(type="header") { @VERSION("0.3"); @USE-PACKAGE(name="cgbcs-pvre", version="1.0", path="../../symbols.rnl") }
subckt L2_TM_PVRE_PVRE_DRV (cm dac bias buf g)
parameters rin=1k edac=0
Xdn (dac d g) L3_TM_PVRE_LTC2972_SET ecmd=edac
Rin (d sum) resistor r=rin
Rf (buf sum) resistor r=3k
Cf (buf sum) capacitor c=10n
Xu4 (cm sum buf bias g) L3_TM_PVRE_LT1355
// @RNL {
//   #Xdn @PLACE(-38, 2);
//   #Rin @PLACE(-19, 2);
//   (-19, 3.45) @TEXT("Rin", size=1.03, halign="middle");
//   #Rf @PLACE(0, 13) => @ORIENT("R180");
//   (0, 14.45) @TEXT("Rf  3 kOhm", size=1.03, halign="middle");
//   #Cf @PLACE(0, 21) => @ORIENT("R180");
//   (0, 22.45) @TEXT("Cf  10 nF", size=1.03, halign="middle");
//   #Xu4 @PLACE(0, 0);
//   %port_cm = $IO_PORT @ATTACH &cm => @PLACE(-24,-2) => @ORIENT("R0");
//   &cm @WIRE(mode="straight") {%port_cm:p #Xu4:1};
//   %port_bias = $IO_PORT @ATTACH &bias => @PLACE(5,7) => @ORIENT("R180");
//   &bias @WIRE(mode="straight") {%port_bias:p (-2, 7) #Xu4:4};
//   %ground1 = $GROUND @ATTACH &g => @PLACE(-2,-9);
//   &g @WIRE(mode="straight") {#Xu4:5 %ground1:p};
//   %j2 = (-9, 2);
//   $JUNCTION @ATTACH %j2;
//   %j3 = (14, 0);
//   $JUNCTION @ATTACH %j3;
//   &sum @WIRE(mode="straight") {%j2 #Xu4:2};
//   &buf @WIRE(mode="straight") {#Xu4:3 %j3};
//   %port_buf = $IO_PORT @ATTACH &buf => @PLACE(21,0) => @ORIENT("R180");
//   &buf @WIRE(mode="straight") {%j3 %port_buf:p};
//   %port_dac = $IO_PORT @ATTACH &dac => @PLACE(-56,2) => @ORIENT("R0");
//   &dac @WIRE(mode="straight") {%port_dac:p #Xdn:1};
//   &d @WIRE(mode="straight") {#Xdn:2 (-26, 2) (-26, 2) #Rin:1};
//   %ground4 = $GROUND @ATTACH &g => @PLACE(-38,-6);
//   &g @WIRE(mode="straight") {#Xdn:3 %ground4:p};
//   &sum @WIRE(mode="straight") {#Rin:2 %j2};
//   %j5 = (-9, 13);
//   $JUNCTION @ATTACH %j5;
//   %j6 = (14, 13);
//   $JUNCTION @ATTACH %j6;
//   &sum @WIRE(mode="straight") {%j2 %j5 #Rf:2};
//   &buf @WIRE(mode="straight") {#Rf:1 %j6 %j3};
//   &sum @WIRE(mode="straight") {%j5 (-9, 21) #Cf:2};
//   &buf @WIRE(mode="straight") {#Cf:1 (14, 21) %j6};
//   %port_g = $IO_PORT @ATTACH &g => @PLACE(-57,-11) => @ORIENT("R0");
//   %common = $GROUND @ATTACH &g => @PLACE(-54,-13);
//   &g @WIRE(mode="straight") {%port_g:p (-54, -11) %common:p}
// }
ends L2_TM_PVRE_PVRE_DRV
