simulator lang=spectre
// @RNL(type="header") { @VERSION("0.3"); @USE-PACKAGE(name="cgbcs-pvre", version="1.0", path="../../symbols.rnl") }
subckt TM_PVRE_CARD_PCB (buf card plug g)
parameters ccard=100u ratiosq=42.86 lenmm=76.2 cum=35 rreturn=5m lmm=0.5n cmm=0.12p rcontact=10m lcontact=1n rneck=2m lneck=1n lcap=0.7n esr=10m
Rsense (buf after10) resistor r=10
Xneck (after10 card g) TM_PVRE_LINE rs=rneck le=lneck
Xmount (card store g) TM_PVRE_LINE rs=esr le=lcap
Ccard (store g) capacitor c=ccard
Xs1 (card n1 g) TM_PVRE_PI_SECTION rr=(0.01724*ratiosq/cum+rreturn)/4 ll=lmm*lenmm/4 cc=cmm*lenmm/4
Xs2 (n1 n2 g) TM_PVRE_PI_SECTION rr=(0.01724*ratiosq/cum+rreturn)/4 ll=lmm*lenmm/4 cc=cmm*lenmm/4
Xs3 (n2 n3 g) TM_PVRE_PI_SECTION rr=(0.01724*ratiosq/cum+rreturn)/4 ll=lmm*lenmm/4 cc=cmm*lenmm/4
Xs4 (n3 pin g) TM_PVRE_PI_SECTION rr=(0.01724*ratiosq/cum+rreturn)/4 ll=lmm*lenmm/4 cc=cmm*lenmm/4
Xcontact (pin plug g) TM_PVRE_LINE rs=rcontact le=lcontact
// @RNL {
//   #Rsense @PLACE(0, 0);
//   (0, -3.7) @TEXT("r=10", size=0.68, halign="middle");
//   #Xneck @PLACE(35, 0);
//   #Xmount @PLACE(70, 0);
//   #Ccard @PLACE(105, 0);
//   (105, -3.7) @TEXT("c=ccard", size=0.68, halign="middle");
//   #Xs1 @PLACE(0, -23);
//   #Xs2 @PLACE(35, -23);
//   #Xs3 @PLACE(70, -23);
//   #Xs4 @PLACE(105, -23);
//   #Xcontact @PLACE(0, -46);
//   %io_buf = $IO_PORT @ATTACH &buf => @PLACE(-9, 0) => @ORIENT("R0");
//   &buf @WIRE(mode="straight") {%io_buf:p #Rsense:1};
//   %io_card = $IO_PORT @ATTACH &card => @PLACE(51, 0) => @ORIENT("R180");
//   &card @WIRE(mode="straight") {%io_card:p #Xneck:2};
//   %io_plug = $IO_PORT @ATTACH &plug => @PLACE(16, -46) => @ORIENT("R180");
//   &plug @WIRE(mode="straight") {%io_plug:p #Xcontact:2};
//   %io_g = $IO_PORT @ATTACH &g => @PLACE(35, -11) => @ORIENT("R90");
//   &g @WIRE(mode="straight") {%io_g:p #Xneck:3};
//   &after10 @WIRE(mode="straight") {#Rsense:2 #Xneck:1};
//   &store @WIRE(mode="straight") {#Xmount:2 #Ccard:1};
//   &n1 @WIRE(mode="straight") {#Xs1:2 #Xs2:1};
//   &n2 @WIRE(mode="straight") {#Xs2:2 #Xs3:1};
//   &n3 @WIRE(mode="straight") {#Xs3:2 #Xs4:1};
//   &pin @WIRE(mode="straight") {#Xs4:2 (117, -23) (117, -39) (-12, -39) (-12, -46) #Xcontact:1};
//   &card @WIRE(mode="straight") {#Xneck:2 #Xmount:1};
//   &card @WIRE(mode="straight") {#Xneck:2 (47, 0) (47, -16) (-12, -16) (-12, -23) #Xs1:1};
//   %ground0 = $GROUND @ATTACH &g => @PLACE(70, -7);
//   &g @WIRE(mode="straight") {#Xmount:3 %ground0:p};
//   %ground1 = $GROUND @ATTACH &g => @PLACE(110, 0);
//   &g @WIRE(mode="straight") {#Ccard:2 %ground1:p};
//   %ground2 = $GROUND @ATTACH &g => @PLACE(0, -30);
//   &g @WIRE(mode="straight") {#Xs1:3 %ground2:p};
//   %ground3 = $GROUND @ATTACH &g => @PLACE(35, -30);
//   &g @WIRE(mode="straight") {#Xs2:3 %ground3:p};
//   %ground4 = $GROUND @ATTACH &g => @PLACE(70, -30);
//   &g @WIRE(mode="straight") {#Xs3:3 %ground4:p};
//   %ground5 = $GROUND @ATTACH &g => @PLACE(105, -30);
//   &g @WIRE(mode="straight") {#Xs4:3 %ground5:p};
//   %ground6 = $GROUND @ATTACH &g => @PLACE(0, -53);
//   &g @WIRE(mode="straight") {#Xcontact:3 %ground6:p}
// }
ends TM_PVRE_CARD_PCB
