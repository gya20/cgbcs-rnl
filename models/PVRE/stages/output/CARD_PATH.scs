simulator lang=spectre
// @RNL(type="header") { @VERSION("0.3"); @USE-PACKAGE(name="cgbcs-pvre", version="1.0", path="../../symbols.rnl") }
subckt L2_TM_PVRE_CARD_PATH (plug pad die g)
parameters cpad=1p
Xfeed (plug pad g) L4_TM_PVRE_LINE rs=20m le=1n
Cboard (pad g) capacitor c=cpad
Xbond (pad die g) L4_TM_PVRE_LINE rs=50m le=2n
// @RNL {
//   #Xfeed @PLACE(0, 0);
//   #Cboard @PLACE(15, -7) => @ORIENT("R270");
//   (16.5, -7) @TEXT("Cboard  cpad", size=0.76, halign="start");
//   #Xbond @PLACE(31, 0);
//   %io_plug = $IO_PORT @ATTACH &plug => @PLACE(-14, 0) => @ORIENT("R0");
//   &plug @WIRE(mode="straight") {%io_plug:p #Xfeed:1};
//   %io_pad = $IO_PORT @ATTACH &pad => @PLACE(14, 0) => @ORIENT("R180");
//   &pad @WIRE(mode="straight") {%io_pad:p #Xfeed:2};
//   %io_die = $IO_PORT @ATTACH &die => @PLACE(45, 0) => @ORIENT("R180");
//   &die @WIRE(mode="straight") {%io_die:p #Xbond:2};
//   %io_g = $IO_PORT @ATTACH &g => @PLACE(0, -11) => @ORIENT("R90");
//   &g @WIRE(mode="straight") {%io_g:p #Xfeed:3};
//   &pad @WIRE(mode="straight") {#Xfeed:2 (15, 0) #Cboard:1};
//   &pad @WIRE(mode="straight") {#Cboard:1 (15, -2) (21, -2) (21, 0) #Xbond:1};
//   %ground0 = $GROUND @ATTACH &g => @PLACE(15, -12);
//   &g @WIRE(mode="straight") {#Cboard:2 %ground0:p};
//   %ground1 = $GROUND @ATTACH &g => @PLACE(31, -7);
//   &g @WIRE(mode="straight") {#Xbond:3 %ground1:p}
// }
ends L2_TM_PVRE_CARD_PATH
