simulator lang=spectre
// @RNL(type="header") { @VERSION("0.3"); @USE-PACKAGE(name="cgbcs-vpfb-vmfb", version="1.0", path="../symbols.rnl") }

subckt L4_TM_COMMON_NOISE (p q g)
parameters ew=0
Rn (w g) resistor r=1k
En (p q w g) vcvs gain=ew/4.07035n
// @RNL {
//   #Rn @PLACE(0, -3) => @ORIENT("R270");
//   (1.5, -3) @TEXT("Rn  1k", size=0.76, halign="start");
//   #En @PLACE(15, 0);
//   (17.4, 1.4) @TEXT("En  en scale", size=0.76, halign="start");
//   %j1 = (0, 1);
//   $JUNCTION @ATTACH %j1;
//   &w @WIRE(mode="straight") {#Rn:1 %j1};
//   &w @WIRE(mode="straight") {%j1 #En:3};
//   %ground2 = $GROUND @ATTACH &g => @PLACE(0,-9);
//   &g @WIRE(mode="straight") {#Rn:2 %ground2:p};
//   %ground3 = $GROUND @ATTACH &g => @PLACE(9,-4);
//   &g @WIRE(mode="straight") {#En:4 (9, -1) %ground3:p};
//   %port_p = $IO_PORT @ATTACH &p => @PLACE(21,6) => @ORIENT("R180");
//   &p @WIRE(mode="straight") {#En:1 (15, 6) %port_p:p};
//   %port_q = $IO_PORT @ATTACH &q => @PLACE(21,-6) => @ORIENT("R180");
//   &q @WIRE(mode="straight") {#En:2 (15, -6) %port_q:p};
//   %port_g = $IO_PORT @ATTACH &g => @PLACE(-9,-11) => @ORIENT("R0");
//   %common = $GROUND @ATTACH &g => @PLACE(-6,-13);
//   &g @WIRE(mode="straight") {%port_g:p (-6, -11) %common:p}
// }
ends L4_TM_COMMON_NOISE
