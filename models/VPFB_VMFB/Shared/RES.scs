simulator lang=spectre
// @RNL(type="header") { @VERSION("0.3"); @USE-PACKAGE(name="cgbcs-vpfb-vmfb", version="1.0", path="../symbols.rnl") }

subckt L5_TM_COMMON_RES (a b)
parameters r=1k dr=0 ls=0.5n cp=0.05p
Rbody (a t) resistor r=r*(1+dr)
Gs (b h t b) vccs gm=0.1
Cx (h b) capacitor c=ls*0.01
Rx (h b) resistor r=1T isnoisy=no
Gi (t b h b) vccs gm=0.1
Cpar (a b) capacitor c=cp
// @RNL {
//   #Rbody @PLACE(0, 4);
//   (0, 5.45) @TEXT("Rbody  r*(1+dr)", size=0.76, halign="middle");
//   #Gs @PLACE(0, -20) => @ORIENT("MX");
//   (2.4, -18.6) @TEXT("Gs  0.1", size=0.76, halign="start");
//   #Cx @PLACE(13, -20) => @ORIENT("R270");
//   (14.5, -20) @TEXT("Cx  ls*0.01", size=0.76, halign="start");
//   #Rx @PLACE(26, -20) => @ORIENT("R270");
//   (27.5, -20) @TEXT("Rx  1T", size=0.76, halign="start");
//   #Gi @PLACE(22, 4) => @ORIENT("R90");
//   (24.4, 5.4) @TEXT("Gi  0.1", size=0.76, halign="start");
//   #Cpar @PLACE(12, 16);
//   (12, 17.45) @TEXT("Cpar  cp", size=0.76, halign="middle");
//   %j1 = (-9, 4);
//   $JUNCTION @ATTACH %j1;
//   %port_a = $IO_PORT @ATTACH &a => @PLACE(-16,4) => @ORIENT("R0");
//   &a @WIRE(mode="straight") {%port_a:p %j1 #Rbody:1};
//   &t @WIRE(mode="straight") {#Rbody:2 #Gi:1};
//   (11, 5) @TEXT("t", size=0.85, halign="middle", valign="middle");
//   %j2 = (35, 4);
//   $JUNCTION @ATTACH %j2;
//   %port_b = $IO_PORT @ATTACH &b => @PLACE(42,4) => @ORIENT("R180");
//   &b @WIRE(mode="straight") {#Gi:2 %j2 %port_b:p};
//   &a @WIRE(mode="straight") {%j1 (-9, 16) #Cpar:1};
//   &b @WIRE(mode="straight") {#Cpar:2 (35, 16) %j2};
//   &t @WIRE(mode="straight") {#Gs:3 (-10, -21)};
//   (-12, -21) @TEXT("t", size=0.96, halign="middle", valign="middle");
//   &b @WIRE(mode="straight") {#Gs:4 (-10, -19)};
//   (-12, -19) @TEXT("b", size=0.96, halign="middle", valign="middle");
//   &h @WIRE(mode="straight") {#Gi:3 (21, -3) (18, -3)};
//   (17, -3) @TEXT("h", size=0.96, halign="middle", valign="middle");
//   &b @WIRE(mode="straight") {#Gi:4 (23, -1) (26, -1)};
//   (27, -1) @TEXT("b", size=0.96, halign="middle", valign="middle");
//   %j3 = (13, -13);
//   $JUNCTION @ATTACH %j3;
//   &h @WIRE(mode="straight") {#Gs:2 (0, -13) %j3 (26, -13) #Rx:1};
//   &h @WIRE(mode="straight") {%j3 #Cx:1};
//   (6, -12) @TEXT("h", size=0.96, halign="middle", valign="middle");
//   %j4 = (13, -27);
//   $JUNCTION @ATTACH %j4;
//   &b @WIRE(mode="straight") {#Gs:1 (0, -27) %j4 (26, -27) #Rx:2};
//   &b @WIRE(mode="straight") {%j4 #Cx:2};
//   (6, -26) @TEXT("b", size=0.96, halign="middle", valign="middle");
//   (13, -10) @TEXT("ESL integrator", size=1.05, halign="middle", valign="middle")
// }
ends L5_TM_COMMON_RES
