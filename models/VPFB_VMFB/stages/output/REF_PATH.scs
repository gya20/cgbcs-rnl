simulator lang=spectre
// @RNL(type="header") { @VERSION("0.3"); @USE-PACKAGE(name="cgbcs-vpfb-vmfb", version="1.0", path="../../symbols.rnl") }
subckt TM_REF_REF_PATH (drive pad die g)
parameters ceff=220u lb=2n cpin=2p
Riso (drive pad) resistor r=1
Xbulk (pad g) TM_REF_CAPBR rr=2m ll=0.1n cc=ceff
Xhf (pad g) TM_REF_CAPBR rr=0.22 ll=0.15n cc=100n
Xbond (pad die g) TM_REF_LINE rs=50m le=lb
Cpin (die g) capacitor c=cpin
// @RNL {
//   #Riso @PLACE(0, 0);
//   (0, -3.7) @TEXT("r=1", size=0.68, halign="middle");
//   #Xbulk @PLACE(35, 0);
//   #Xhf @PLACE(70, 0);
//   #Xbond @PLACE(105, 0);
//   #Cpin @PLACE(0, -23);
//   (0, -26.7) @TEXT("c=cpin", size=0.68, halign="middle");
//   %io_drive = $IO_PORT @ATTACH &drive => @PLACE(-9, 0) => @ORIENT("R0");
//   &drive @WIRE(mode="straight") {%io_drive:p #Riso:1};
//   %io_pad = $IO_PORT @ATTACH &pad => @PLACE(9, 0) => @ORIENT("R180");
//   &pad @WIRE(mode="straight") {%io_pad:p #Riso:2};
//   %io_die = $IO_PORT @ATTACH &die => @PLACE(121, 0) => @ORIENT("R180");
//   &die @WIRE(mode="straight") {%io_die:p #Xbond:2};
//   %io_g = $IO_PORT @ATTACH &g => @PLACE(35, -11) => @ORIENT("R90");
//   &g @WIRE(mode="straight") {%io_g:p #Xbulk:2};
//   &die @WIRE(mode="straight") {#Xbond:2 (117, 0) (117, -19) (-5, -19) (-5, -23) #Cpin:1};
//   &pad @WIRE(mode="straight") {#Riso:2 #Xbulk:1};
//   &pad @WIRE(mode="straight") {#Xbulk:1 (23, 0) (23, 7) (58, 7) (58, 0) #Xhf:1};
//   &pad @WIRE(mode="straight") {#Xhf:1 (58, 0) (58, -6) (93, -6) (93, 0) #Xbond:1};
//   %ground0 = $GROUND @ATTACH &g => @PLACE(70, -7);
//   &g @WIRE(mode="straight") {#Xhf:2 %ground0:p};
//   %ground1 = $GROUND @ATTACH &g => @PLACE(105, -7);
//   &g @WIRE(mode="straight") {#Xbond:3 %ground1:p};
//   %ground2 = $GROUND @ATTACH &g => @PLACE(5, -23);
//   &g @WIRE(mode="straight") {#Cpin:2 %ground2:p}
// }
ends TM_REF_REF_PATH
