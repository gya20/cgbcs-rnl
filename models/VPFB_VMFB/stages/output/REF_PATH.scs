simulator lang=spectre
// @RNL(type="header") { @VERSION("0.3"); @USE-PACKAGE(name="cgbcs-vpfb-vmfb", version="1.0", path="../../symbols.rnl") }
subckt L1_TM_REF_REF_PATH (drive pad die g)
parameters ceff=220u lb=2n cpin=2p
Riso (drive pad) resistor r=1
Xbulk (pad g) L2_TM_REF_CAPBR rr=2m ll=0.1n cc=ceff
Xhf (pad g) L2_TM_REF_CAPBR rr=0.22 ll=0.15n cc=100n
Xbond (pad die g) L3_TM_REF_LINE rs=50m le=lb
Cpin (die g) capacitor c=cpin
// @RNL {
//   #Riso @PLACE(0, 0);
//   (0, 1.45) @TEXT("Riso  1", size=0.76, halign="middle");
//   #Xbulk @PLACE(10, -7);
//   #Xhf @PLACE(22, -7);
//   #Xbond @PLACE(38, 0);
//   #Cpin @PLACE(52, -7) => @ORIENT("R270");
//   (53.5, -7) @TEXT("Cpin  cpin", size=0.76, halign="start");
//   %io_drive = $IO_PORT @ATTACH &drive => @PLACE(-9, 0) => @ORIENT("R0");
//   &drive @WIRE(mode="straight") {%io_drive:p #Riso:1};
//   %io_pad = $IO_PORT @ATTACH &pad => @PLACE(9, 0) => @ORIENT("R180");
//   &pad @WIRE(mode="straight") {%io_pad:p #Riso:2};
//   %io_die = $IO_PORT @ATTACH &die => @PLACE(52, 0) => @ORIENT("R180");
//   &die @WIRE(mode="straight") {%io_die:p #Xbond:2};
//   %io_g = $IO_PORT @ATTACH &g => @PLACE(10, -17) => @ORIENT("R90");
//   &g @WIRE(mode="straight") {%io_g:p #Xbulk:2};
//   &die @WIRE(mode="straight") {#Xbond:2 (52, 0) #Cpin:1};
//   &pad @WIRE(mode="straight") {#Riso:2 (10, 0) #Xbulk:1};
//   &pad @WIRE(mode="straight") {#Xbulk:1 (10, -1) (22, -1) #Xhf:1};
//   &pad @WIRE(mode="straight") {#Xhf:1 (22, -1) (28, -1) (28, 0) #Xbond:1};
//   %ground0 = $GROUND @ATTACH &g => @PLACE(22, -13);
//   &g @WIRE(mode="straight") {#Xhf:2 %ground0:p};
//   %ground1 = $GROUND @ATTACH &g => @PLACE(38, -7);
//   &g @WIRE(mode="straight") {#Xbond:3 %ground1:p};
//   %ground2 = $GROUND @ATTACH &g => @PLACE(52, -12);
//   &g @WIRE(mode="straight") {#Cpin:2 %ground2:p}
// }
ends L1_TM_REF_REF_PATH
