simulator lang=spectre
// @RNL(type="header") { @VERSION("0.3"); @USE-PACKAGE(name="cgbcs-vpfb-vmfb", version="1.0", path="../../symbols.rnl") }
subckt L1_TM_REF_FAST (servo pad drive bias g)
parameters rofast=3.98 fo=2036 f2=1.481M
Xu (servo nf drive bias g) L2_TM_REF_LT6202 ro=rofast fo=fo f2=f2
Rf (pad nf) resistor r=100
Rh (nf nc) resistor r=20k
Ch (nc drive) capacitor c=4.7n
// @RNL {
//   #Xu @PLACE(0, 0);
//   #Rf @PLACE(-18, 2);
//   (-18, 3.45) @TEXT("Rf  100", size=0.76, halign="middle");
//   #Rh @PLACE(-4, 13);
//   (-4, 14.45) @TEXT("Rh  20k", size=0.76, halign="middle");
//   #Ch @PLACE(8, 13);
//   (8, 14.45) @TEXT("Ch  4.7n", size=0.76, halign="middle");
//   %port_servo = $IO_PORT @ATTACH &servo => @PLACE(-24,-2) => @ORIENT("R0");
//   &servo @WIRE(mode="straight") {%port_servo:p #Xu:1};
//   %port_bias = $IO_PORT @ATTACH &bias => @PLACE(5,7) => @ORIENT("R180");
//   &bias @WIRE(mode="straight") {%port_bias:p (-2, 7) #Xu:4};
//   %ground1 = $GROUND @ATTACH &g => @PLACE(-2,-9);
//   &g @WIRE(mode="straight") {#Xu:5 %ground1:p};
//   %j2 = (-9, 2);
//   $JUNCTION @ATTACH %j2;
//   %j3 = (14, 0);
//   $JUNCTION @ATTACH %j3;
//   &nf @WIRE(mode="straight") {%j2 #Xu:2};
//   &drive @WIRE(mode="straight") {#Xu:3 %j3};
//   %port_drive = $IO_PORT @ATTACH &drive => @PLACE(21,0) => @ORIENT("R180");
//   &drive @WIRE(mode="straight") {%j3 %port_drive:p};
//   %port_pad = $IO_PORT @ATTACH &pad => @PLACE(-27,2) => @ORIENT("R0");
//   &pad @WIRE(mode="straight") {%port_pad:p #Rf:1};
//   &nf @WIRE(mode="straight") {#Rf:2 %j2};
//   &nf @WIRE(mode="straight") {%j2 (-9, 13) #Rh:1};
//   &nc @WIRE(mode="straight") {#Rh:2 #Ch:1};
//   &drive @WIRE(mode="straight") {#Ch:2 (14, 13) %j3};
//   %port_g = $IO_PORT @ATTACH &g => @PLACE(-30,-11) => @ORIENT("R0");
//   %common = $GROUND @ATTACH &g => @PLACE(-27,-13);
//   &g @WIRE(mode="straight") {%port_g:p (-27, -11) %common:p}
// }
ends L1_TM_REF_FAST
