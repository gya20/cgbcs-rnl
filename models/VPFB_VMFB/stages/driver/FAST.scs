simulator lang=spectre
// @RNL(type="header") { @VERSION("0.3"); @USE-PACKAGE(name="cgbcs-vpfb-vmfb", version="1.0", path="../../symbols.rnl") }
subckt TM_REF_FAST (servo pad drive bias g)
parameters rofast=3.98 fo=2036 f2=1.481M
Xu (servo nf drive bias g) TM_REF_LT6202 ro=rofast fo=fo f2=f2
Rf (pad nf) resistor r=100
Rh (nf nc) resistor r=20k
Ch (nc drive) capacitor c=4.7n
// @RNL {
//   #Xu @PLACE(0, 0);
//   #Rf @PLACE(35, 0);
//   (35, -3.7) @TEXT("r=100", size=0.68, halign="middle");
//   #Rh @PLACE(70, 0);
//   (70, -3.7) @TEXT("r=20k", size=0.68, halign="middle");
//   #Ch @PLACE(105, 0);
//   (105, -3.7) @TEXT("c=4.7n", size=0.68, halign="middle");
//   %io_servo = $IO_PORT @ATTACH &servo => @PLACE(-16, 1) => @ORIENT("R0");
//   &servo @WIRE(mode="straight") {%io_servo:p #Xu:1};
//   %io_pad = $IO_PORT @ATTACH &pad => @PLACE(26, 0) => @ORIENT("R0");
//   &pad @WIRE(mode="straight") {%io_pad:p #Rf:1};
//   %io_drive = $IO_PORT @ATTACH &drive => @PLACE(16, 0) => @ORIENT("R180");
//   &drive @WIRE(mode="straight") {%io_drive:p #Xu:3};
//   %io_bias = $IO_PORT @ATTACH &bias => @PLACE(-3, -11) => @ORIENT("R90");
//   &bias @WIRE(mode="straight") {%io_bias:p #Xu:4};
//   %io_g = $IO_PORT @ATTACH &g => @PLACE(3, -11) => @ORIENT("R90");
//   &g @WIRE(mode="straight") {%io_g:p #Xu:5};
//   &drive @WIRE(mode="straight") {#Xu:3 (12, 0) (12, -3) (110, -3) (110, 0) #Ch:2};
//   &nc @WIRE(mode="straight") {#Rh:2 #Ch:1};
//   &nf @WIRE(mode="straight") {#Xu:2 (-12, -1) (-12, 7) (40, 7) (40, 0) #Rf:2};
//   &nf @WIRE(mode="straight") {#Rf:2 #Rh:1}
// }
ends TM_REF_FAST
