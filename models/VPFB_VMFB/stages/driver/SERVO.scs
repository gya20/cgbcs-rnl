simulator lang=spectre
// @RNL(type="header") { @VERSION("0.3"); @USE-PACKAGE(name="cgbcs-vpfb-vmfb", version="1.0", path="../../symbols.rnl") }
subckt L1_TM_REF_SERVO (set pad servo bias g)
Xu (set ns servo bias g) L2_TM_REF_ADA4522
Rs (pad ns) resistor r=1k
Cs (ns servo) capacitor c=100n
// @RNL {
//   #Xu @PLACE(0, 0);
//   #Rs @PLACE(-16, 2);
//   (-16, 3.45) @TEXT("Rs  1k", size=0.76, halign="middle");
//   #Cs @PLACE(0, 12);
//   (0, 13.45) @TEXT("Cs  100n", size=0.76, halign="middle");
//   %port_set = $IO_PORT @ATTACH &set => @PLACE(-24,-2) => @ORIENT("R0");
//   &set @WIRE(mode="straight") {%port_set:p #Xu:1};
//   %port_bias = $IO_PORT @ATTACH &bias => @PLACE(5,7) => @ORIENT("R180");
//   &bias @WIRE(mode="straight") {%port_bias:p (-2, 7) #Xu:4};
//   %ground1 = $GROUND @ATTACH &g => @PLACE(-2,-9);
//   &g @WIRE(mode="straight") {#Xu:5 %ground1:p};
//   %j2 = (-9, 2);
//   $JUNCTION @ATTACH %j2;
//   %j3 = (14, 0);
//   $JUNCTION @ATTACH %j3;
//   &ns @WIRE(mode="straight") {%j2 #Xu:2};
//   &servo @WIRE(mode="straight") {#Xu:3 %j3};
//   %port_servo = $IO_PORT @ATTACH &servo => @PLACE(21,0) => @ORIENT("R180");
//   &servo @WIRE(mode="straight") {%j3 %port_servo:p};
//   %port_pad = $IO_PORT @ATTACH &pad => @PLACE(-26,2) => @ORIENT("R0");
//   &pad @WIRE(mode="straight") {%port_pad:p #Rs:1};
//   &ns @WIRE(mode="straight") {#Rs:2 %j2};
//   &ns @WIRE(mode="straight") {%j2 (-9, 12) #Cs:1};
//   &servo @WIRE(mode="straight") {#Cs:2 (14, 12) %j3};
//   %port_g = $IO_PORT @ATTACH &g => @PLACE(-28,-11) => @ORIENT("R0");
//   %common = $GROUND @ATTACH &g => @PLACE(-25,-13);
//   &g @WIRE(mode="straight") {%port_g:p (-25, -11) %common:p}
// }
ends L1_TM_REF_SERVO
