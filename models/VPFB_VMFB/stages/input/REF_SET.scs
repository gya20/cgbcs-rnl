simulator lang=spectre
// @RNL(type="header") { @VERSION("0.3"); @USE-PACKAGE(name="cgbcs-vpfb-vmfb", version="1.0", path="../../symbols.rnl") }
subckt L2_TM_REF_REF_SET (ref set g)
parameters rt=240
Rt (ref div) resistor r=rt
Rb (div g) resistor r=10k
Rf (div set) resistor r=4.99k
Cf (set g) capacitor c=20u
Rl (set g) resistor r=1T
// @RNL {
//   #Rt @PLACE(0, 0);
//   (0, 1.45) @TEXT("Rt  rt", size=0.76, halign="middle");
//   #Rb @PLACE(8, -7) => @ORIENT("R270");
//   (9.5, -7) @TEXT("Rb  10k", size=0.76, halign="start");
//   #Rf @PLACE(18, 0);
//   (18, 1.45) @TEXT("Rf  4.99k", size=0.76, halign="middle");
//   #Cf @PLACE(28, -7) => @ORIENT("R270");
//   (29.5, -7) @TEXT("Cf  20u", size=0.76, halign="start");
//   #Rl @PLACE(39, -7) => @ORIENT("R270");
//   (40.5, -7) @TEXT("Rl  1T", size=0.76, halign="start");
//   %port_ref = $IO_PORT @ATTACH &ref => @PLACE(-8,0) => @ORIENT("R0");
//   &ref @WIRE(mode="straight") {%port_ref:p #Rt:1};
//   %j1 = (8, 0);
//   $JUNCTION @ATTACH %j1;
//   &div @WIRE(mode="straight") {#Rt:2 %j1 #Rf:1};
//   &div @WIRE(mode="straight") {%j1 #Rb:1};
//   %j2 = (28, 0);
//   $JUNCTION @ATTACH %j2;
//   %j3 = (39, 0);
//   $JUNCTION @ATTACH %j3;
//   %port_set = $IO_PORT @ATTACH &set => @PLACE(47,0) => @ORIENT("R180");
//   &set @WIRE(mode="straight") {#Rf:2 %j2 %j3 %port_set:p};
//   &set @WIRE(mode="straight") {%j2 #Cf:1};
//   &set @WIRE(mode="straight") {%j3 #Rl:1};
//   %ground4 = $GROUND @ATTACH &g => @PLACE(8,-13);
//   &g @WIRE(mode="straight") {#Rb:2 %ground4:p};
//   %ground5 = $GROUND @ATTACH &g => @PLACE(28,-13);
//   &g @WIRE(mode="straight") {#Cf:2 %ground5:p};
//   %ground6 = $GROUND @ATTACH &g => @PLACE(39,-13);
//   &g @WIRE(mode="straight") {#Rl:2 %ground6:p};
//   %port_g = $IO_PORT @ATTACH &g => @PLACE(-12,-15) => @ORIENT("R0");
//   %common = $GROUND @ATTACH &g => @PLACE(-9,-17);
//   &g @WIRE(mode="straight") {%port_g:p (-9, -15) %common:p}
// }
ends L2_TM_REF_REF_SET
