simulator lang=spectre
// @RNL(type="header") { @VERSION("0.3"); @USE-PACKAGE(name="cgbcs-vpfb-vmfb", version="1.0", path="../../symbols.rnl") }

subckt L1_TM_REF_REF_INPUT (vin bias ref g)
Rs (vin vf) L5_TM_COMMON_RES r=10
Cin (vf g) L5_TM_COMMON_CAP c=10u esr=20m esl=0.5n
Ch (vf g) L5_TM_COMMON_CAP c=100n esr=30m esl=0.25n
Xu1 (vf bias ref g) L2_TM_REF_LTC6655B
Co (ref g) L5_TM_COMMON_CAP c=10u esr=20m esl=0.5n
Coh (ref g) L5_TM_COMMON_CAP c=100n esr=30m esl=0.25n
// @RNL {
//   #Rs @PLACE(0, 0);
//   (0, 1.45) @TEXT("Rs  10", size=0.76, halign="middle");
//   #Cin @PLACE(9, -7) => @ORIENT("R270");
//   (10.5, -7) @TEXT("Cin  10u", size=0.76, halign="start");
//   #Ch @PLACE(18, -7) => @ORIENT("R270");
//   (19.5, -7) @TEXT("Ch  100n", size=0.76, halign="start");
//   #Xu1 @PLACE(36, 0);
//   #Co @PLACE(53, -7) => @ORIENT("R270");
//   (54.5, -7) @TEXT("Co  10u", size=0.76, halign="start");
//   #Coh @PLACE(63, -7) => @ORIENT("R270");
//   (64.5, -7) @TEXT("Coh  100n", size=0.76, halign="start");
//   %io_vin = $IO_PORT @ATTACH &vin => @PLACE(-9, 0) => @ORIENT("R0");
//   &vin @WIRE(mode="straight") {%io_vin:p #Rs:1};
//   %io_bias = $IO_PORT @ATTACH &bias => @PLACE(33, -11) => @ORIENT("R90");
//   &bias @WIRE(mode="straight") {%io_bias:p #Xu1:2};
//   %io_ref = $IO_PORT @ATTACH &ref => @PLACE(52, 0) => @ORIENT("R180");
//   &ref @WIRE(mode="straight") {%io_ref:p #Xu1:3};
//   %io_g = $IO_PORT @ATTACH &g => @PLACE(9, -16) => @ORIENT("R90");
//   &g @WIRE(mode="straight") {%io_g:p #Cin:2};
//   &ref @WIRE(mode="straight") {#Xu1:3 (53, 0) #Co:1};
//   &ref @WIRE(mode="straight") {#Co:1 (53, -2) (63, -2) #Coh:1};
//   &vf @WIRE(mode="straight") {#Rs:2 (9, 0) #Cin:1};
//   &vf @WIRE(mode="straight") {#Cin:1 (9, -2) (18, -2) #Ch:1};
//   &vf @WIRE(mode="straight") {#Ch:1 (18, -2) (24, -2) (24, 0) #Xu1:1};
//   %ground0 = $GROUND @ATTACH &g => @PLACE(18, -12);
//   &g @WIRE(mode="straight") {#Ch:2 %ground0:p};
//   %ground1 = $GROUND @ATTACH &g => @PLACE(39, -7);
//   &g @WIRE(mode="straight") {#Xu1:4 %ground1:p};
//   %ground2 = $GROUND @ATTACH &g => @PLACE(53, -12);
//   &g @WIRE(mode="straight") {#Co:2 %ground2:p};
//   %ground3 = $GROUND @ATTACH &g => @PLACE(63, -12);
//   &g @WIRE(mode="straight") {#Coh:2 %ground3:p}
// }
ends L1_TM_REF_REF_INPUT
