simulator lang=spectre
// @RNL(type="header") { @VERSION("0.3"); @USE-PACKAGE(name="cgbcs-vpfb-vmfb", version="1.0", path="../symbols.rnl") }

subckt L1_TM_REF_REF_CH (ref bias pad die g)
parameters rt=240 rofast=4.2263 fo=1023.48 f2=2.6741M rz=557.893 esrb=2m eslb=0.1n ceff=220u lb=2n cpin=2p
Rt (ref div) L5_TM_COMMON_RES r=rt
Rb (div g) L5_TM_COMMON_RES r=10k
Rset (div set) L5_TM_COMMON_RES r=4.99k
Cset (set g) L5_TM_COMMON_CAP c=10u np=2 esr=40m esl=1n rleak=2T
X_ADA4522 (set ns servo bias g) L2_TM_REF_ADA4522
Rs (pad ns) L5_TM_COMMON_RES r=1k
Cs (ns servo) L5_TM_COMMON_CAP c=100n esr=30m esl=0.25n
X_LT6202 (servo nf drive bias g) L2_TM_REF_LT6202 ro=rofast rz=rz fo=fo f2=f2
Rf (pad nf) L5_TM_COMMON_RES r=100
Rh (nf nc) L5_TM_COMMON_RES r=20k
Ch (nc drive) L5_TM_COMMON_CAP c=4.7n esr=30m esl=0.25n
Riso (drive pad) L5_TM_COMMON_RES r=1
Xbulk (pad g) L5_TM_COMMON_CAP c=22u np=12 kc=ceff/(12*22u) esr=12*esrb esl=12*eslb
Xhf (snub g) L5_TM_COMMON_CAP c=100n esr=10m esl=0.1n
Xbond (pad die g) L4_TM_COMMON_LINE rs=50m le=lb
Cpin (die g) capacitor c=cpin
Rdam (pad snub) L5_TM_COMMON_RES r=0.22 ls=0.05n
// @RNL {
//   #Rt @PLACE(-47, -2);
//   (-47, -0.55) @TEXT("Rt", size=1.03, halign="middle");
//   #Rb @PLACE(-40, -10) => @ORIENT("R270");
//   (-38.5, -10) @TEXT("Rb  10 kOhm", size=1.03, halign="start");
//   #Rset @PLACE(-32, -2);
//   (-32, -0.55) @TEXT("Rset  4.99 kOhm", size=1.03, halign="middle");
//   #Cset @PLACE(-23, -10) => @ORIENT("R270");
//   (-21.5, -10) @TEXT("2 x 10 uF", size=1.03, halign="start");
//   #X_ADA4522 @PLACE(3, 0);
//   #Rs @PLACE(6, 26) => @ORIENT("R180");
//   (6, 27.45) @TEXT("Rs  1 kOhm", size=1.03, halign="middle");
//   #Cs @PLACE(3, 13);
//   (3, 14.45) @TEXT("Cs  100 nF", size=1.03, halign="middle");
//   #X_LT6202 @PLACE(38, 0);
//   #Rf @PLACE(43, 20) => @ORIENT("R180");
//   (43, 21.45) @TEXT("Rf  100 Ohm", size=1.03, halign="middle");
//   #Rh @PLACE(34, 13);
//   (34, 14.45) @TEXT("Rh  20 kOhm", size=1.03, halign="middle");
//   #Ch @PLACE(45, 13);
//   (45, 14.45) @TEXT("Ch  4.7 nF", size=1.03, halign="middle");
//   #Riso @PLACE(59, 0);
//   (59, 1.45) @TEXT("Riso  1 Ohm", size=1.03, halign="middle");
//   #Xbulk @PLACE(65, -12) => @ORIENT("R270");
//   (66.5, -12) @TEXT("12 x 22 uF", size=1.03, halign="start");
//   #Xhf @PLACE(77, -17) => @ORIENT("R270");
//   (78.5, -17) @TEXT("Xhf  100 nF", size=1.03, halign="start");
//   #Xbond @PLACE(89, 0);
//   #Cpin @PLACE(102, -10) => @ORIENT("R270");
//   (103.5, -10) @TEXT("Cpin", size=1.03, halign="start");
//   #Rdam @PLACE(77, -6) => @ORIENT("R270");
//   (78.5, -6) @TEXT("Rdam  0.22", size=1.03, halign="start");
//   %port_ref = $IO_PORT @ATTACH &ref => @PLACE(-56,-2) => @ORIENT("R0");
//   &ref @WIRE(mode="straight") {%port_ref:p #Rt:1};
//   %j1 = (-40, -2);
//   $JUNCTION @ATTACH %j1;
//   &div @WIRE(mode="straight") {#Rt:2 %j1 #Rset:1};
//   &div @WIRE(mode="straight") {%j1 #Rb:1};
//   %j2 = (-23, -2);
//   $JUNCTION @ATTACH %j2;
//   &set @WIRE(mode="straight") {#Rset:2 %j2 #X_ADA4522:1};
//   &set @WIRE(mode="straight") {%j2 #Cset:1};
//   %ground3 = $GROUND @ATTACH &g => @PLACE(-40,-16);
//   &g @WIRE(mode="straight") {#Rb:2 %ground3:p};
//   %ground4 = $GROUND @ATTACH &g => @PLACE(-23,-16);
//   &g @WIRE(mode="straight") {#Cset:2 %ground4:p};
//   %j5 = (-8, 13);
//   $JUNCTION @ATTACH %j5;
//   %j6 = (15, 0);
//   $JUNCTION @ATTACH %j6;
//   &ns @WIRE(mode="straight") {#X_ADA4522:2 (-8, 2) %j5 #Cs:1};
//   &ns @WIRE(mode="straight") {%j5 (-8, 26) #Rs:2};
//   &servo @WIRE(mode="straight") {#X_ADA4522:3 %j6 (20, 0) (20, -2) #X_LT6202:1};
//   &servo @WIRE(mode="straight") {#Cs:2 (15, 13) %j6};
//   %j7 = (27, 13);
//   $JUNCTION @ATTACH %j7;
//   %j8 = (52, 0);
//   $JUNCTION @ATTACH %j8;
//   &nf @WIRE(mode="straight") {#X_LT6202:2 (27, 2) %j7 #Rh:1};
//   &nf @WIRE(mode="straight") {%j7 (27, 20) #Rf:2};
//   &nc @WIRE(mode="straight") {#Rh:2 #Ch:1};
//   &drive @WIRE(mode="straight") {#Ch:2 (52, 13) %j8};
//   &drive @WIRE(mode="straight") {#X_LT6202:3 %j8 #Riso:1};
//   %j9 = (65, 0);
//   $JUNCTION @ATTACH %j9;
//   %j10 = (77, 0);
//   $JUNCTION @ATTACH %j10;
//   %j11 = (65, 20);
//   $JUNCTION @ATTACH %j11;
//   %j12 = (65, 26);
//   $JUNCTION @ATTACH %j12;
//   &pad @WIRE(mode="straight") {#Riso:2 %j9 %j10 #Xbond:1};
//   %port_pad = $IO_PORT @ATTACH &pad => @PLACE(73,26) => @ORIENT("R180");
//   &pad @WIRE(mode="straight") {%j9 %j11 %j12 %port_pad:p};
//   &pad @WIRE(mode="straight") {#Rf:1 %j11};
//   &pad @WIRE(mode="straight") {#Rs:1 %j12};
//   &pad @WIRE(mode="straight") {%j9 #Xbulk:1};
//   &pad @WIRE(mode="straight") {%j10 #Rdam:1};
//   &snub @WIRE(mode="straight") {#Rdam:2 #Xhf:1};
//   %j13 = (102, 0);
//   $JUNCTION @ATTACH %j13;
//   %port_die = $IO_PORT @ATTACH &die => @PLACE(111,0) => @ORIENT("R180");
//   &die @WIRE(mode="straight") {#Xbond:2 %j13 %port_die:p};
//   &die @WIRE(mode="straight") {%j13 #Cpin:1};
//   %ground14 = $GROUND @ATTACH &g => @PLACE(65,-18);
//   &g @WIRE(mode="straight") {#Xbulk:2 %ground14:p};
//   %ground15 = $GROUND @ATTACH &g => @PLACE(77,-23);
//   &g @WIRE(mode="straight") {#Xhf:2 %ground15:p};
//   %ground16 = $GROUND @ATTACH &g => @PLACE(102,-16);
//   &g @WIRE(mode="straight") {#Cpin:2 %ground16:p};
//   %ground17 = $GROUND @ATTACH &g => @PLACE(89,-8);
//   &g @WIRE(mode="straight") {#Xbond:3 %ground17:p};
//   %ground18 = $GROUND @ATTACH &g => @PLACE(1,-9);
//   &g @WIRE(mode="straight") {#X_ADA4522:5 %ground18:p};
//   %ground19 = $GROUND @ATTACH &g => @PLACE(36,-9);
//   &g @WIRE(mode="straight") {#X_LT6202:5 %ground19:p};
//   %port_bias = $IO_PORT @ATTACH &bias => @PLACE(6,8) => @ORIENT("R180");
//   &bias @WIRE(mode="straight") {#X_ADA4522:4 (1, 8) %port_bias:p};
//   &bias @WIRE(mode="straight") {#X_LT6202:4 (36, 8)};
//   (38, 8) @TEXT("bias", size=0.84, halign="middle", valign="middle");
//   (-18, 0) @TEXT("SET", size=0.98, halign="middle", valign="middle");
//   (-6, 5) @TEXT("NS", size=0.98, halign="middle", valign="middle");
//   (20, -4) @TEXT("SERVO", size=0.98, halign="middle", valign="middle");
//   (29, 5) @TEXT("NF", size=0.98, halign="middle", valign="middle");
//   (52, -2) @TEXT("DRIVE", size=0.98, halign="middle", valign="middle");
//   (71, 1.3) @TEXT("PAD", size=0.98, halign="middle", valign="middle");
//   (89, -1.1) @TEXT("bond wire", size=0.98, halign="middle", valign="middle");
//   %port_g = $IO_PORT @ATTACH &g => @PLACE(-59,-25) => @ORIENT("R0");
//   %common = $GROUND @ATTACH &g => @PLACE(-56,-27);
//   &g @WIRE(mode="straight") {%port_g:p (-56, -25) %common:p}
// }
ends L1_TM_REF_REF_CH
