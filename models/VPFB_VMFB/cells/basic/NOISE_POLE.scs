simulator lang=spectre
// @RNL(type="header") { @VERSION("0.3"); @USE-PACKAGE(name="cgbcs-vpfb-vmfb", version="1.0", path="../../symbols.rnl") }

subckt L4_TM_REF_NOISE_POLE (p q g)
parameters fj=1 en=39n fc=1
Rn (w g) resistor r=1k
Cn (w g) capacitor c=1/(6.283185307*1k*fj)
En (p q w g) vcvs gain=(en/4.07035n)*sqrt(0.366468*fc/fj)
// @RNL {
//   #Rn @PLACE(0, -3) => @ORIENT("R270");
//   (1.5, -3) @TEXT("Rn  1k", size=0.76, halign="start");
//   #Cn @PLACE(9, -3) => @ORIENT("R270");
//   (10.5, -3) @TEXT("Cn  C(eq)", size=0.76, halign="start");
//   #En @PLACE(23, 0);
//   (25.4, 1.4) @TEXT("En  Av", size=0.76, halign="start");
//   %j1 = (0, 1);
//   $JUNCTION @ATTACH %j1;
//   &w @WIRE(mode="straight") {#Rn:1 %j1};
//   %j2 = (9, 1);
//   $JUNCTION @ATTACH %j2;
//   &w @WIRE(mode="straight") {%j1 %j2 #En:3};
//   &w @WIRE(mode="straight") {%j2 #Cn:1};
//   %ground3 = $GROUND @ATTACH &g => @PLACE(9,-9);
//   &g @WIRE(mode="straight") {#Cn:2 %ground3:p};
//   %ground4 = $GROUND @ATTACH &g => @PLACE(0,-9);
//   &g @WIRE(mode="straight") {#Rn:2 %ground4:p};
//   %ground5 = $GROUND @ATTACH &g => @PLACE(17,-4);
//   &g @WIRE(mode="straight") {#En:4 (17, -1) %ground5:p};
//   %port_p = $IO_PORT @ATTACH &p => @PLACE(29,6) => @ORIENT("R180");
//   &p @WIRE(mode="straight") {#En:1 (23, 6) %port_p:p};
//   %port_q = $IO_PORT @ATTACH &q => @PLACE(29,-6) => @ORIENT("R180");
//   &q @WIRE(mode="straight") {#En:2 (23, -6) %port_q:p};
//   %port_g = $IO_PORT @ATTACH &g => @PLACE(-9,-11) => @ORIENT("R0");
//   %common = $GROUND @ATTACH &g => @PLACE(-6,-13);
//   &g @WIRE(mode="straight") {%port_g:p (-6, -11) %common:p}
// }
ends L4_TM_REF_NOISE_POLE
