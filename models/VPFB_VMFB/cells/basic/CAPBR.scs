simulator lang=spectre
// @RNL(type="header") { @VERSION("0.3"); @USE-PACKAGE(name="cgbcs-vpfb-vmfb", version="1.0", path="../../symbols.rnl") }
subckt L2_TM_REF_CAPBR (p g)
parameters rr=10m ll=0.5n cc=22u
Xesl (p t g) L3_TM_REF_LINE rs=rr le=ll
Cstore (t g) capacitor c=cc
// @RNL {
//   #Xesl @PLACE(0, 0);
//   #Cstore @PLACE(14, -6) => @ORIENT("R270");
//   (15.5, -6) @TEXT("Cstore  cc", size=0.76, halign="start");
//   %io_p = $IO_PORT @ATTACH &p => @PLACE(-14, 0) => @ORIENT("R0");
//   &p @WIRE(mode="straight") {%io_p:p #Xesl:1};
//   %io_g = $IO_PORT @ATTACH &g => @PLACE(0, -11) => @ORIENT("R90");
//   &g @WIRE(mode="straight") {%io_g:p #Xesl:3};
//   &t @WIRE(mode="straight") {#Xesl:2 (14, 0) #Cstore:1};
//   %ground0 = $GROUND @ATTACH &g => @PLACE(14, -11);
//   &g @WIRE(mode="straight") {#Cstore:2 %ground0:p}
// }
ends L2_TM_REF_CAPBR
