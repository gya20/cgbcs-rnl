simulator lang=spectre
// @RNL(type="header") { @VERSION("0.3"); @USE-PACKAGE(name="cgbcs-vpfb-vmfb", version="1.0", path="../../symbols.rnl") }
subckt TM_REF_REF_NOISE (p q g)
parameters fj=1 en=39n fc=1
X1 (n1 q g) TM_REF_NOISE_DECADE fj=fj*0.001 en=en fc=fc
X2 (n2 n1 g) TM_REF_NOISE_DECADE fj=fj*0.01 en=en fc=fc
X3 (n3 n2 g) TM_REF_NOISE_DECADE fj=fj*0.1 en=en fc=fc
X4 (n4 n3 g) TM_REF_NOISE_DECADE fj=fj*1 en=en fc=fc
X5 (n5 n4 g) TM_REF_NOISE_DECADE fj=fj*10 en=en fc=fc
X6 (n6 n5 g) TM_REF_NOISE_DECADE fj=fj*100 en=en fc=fc
X7 (p n6 g) TM_REF_NOISE_DECADE fj=fj*1000 en=en fc=fc
// @RNL {
//   #X1 @PLACE(0, 0);
//   #X2 @PLACE(35, 0);
//   #X3 @PLACE(70, 0);
//   #X4 @PLACE(105, 0);
//   #X5 @PLACE(0, -23);
//   #X6 @PLACE(35, -23);
//   #X7 @PLACE(70, -23);
//   %io_p = $IO_PORT @ATTACH &p => @PLACE(54, -23) => @ORIENT("R0");
//   &p @WIRE(mode="straight") {%io_p:p #X7:1};
//   %io_q = $IO_PORT @ATTACH &q => @PLACE(16, 0) => @ORIENT("R180");
//   &q @WIRE(mode="straight") {%io_q:p #X1:2};
//   %io_g = $IO_PORT @ATTACH &g => @PLACE(0, -11) => @ORIENT("R90");
//   &g @WIRE(mode="straight") {%io_g:p #X1:3};
//   &n1 @WIRE(mode="straight") {#X1:1 (-12, 0) (-12, 7) (47, 7) (47, 0) #X2:2};
//   &n2 @WIRE(mode="straight") {#X2:1 (23, 0) (23, -6) (82, -6) (82, 0) #X3:2};
//   &n3 @WIRE(mode="straight") {#X3:1 (58, 0) (58, 7) (117, 7) (117, 0) #X4:2};
//   &n4 @WIRE(mode="straight") {#X4:1 (93, 0) (93, -16) (12, -16) (12, -23) #X5:2};
//   &n5 @WIRE(mode="straight") {#X5:1 (-12, -23) (-12, -29) (47, -29) (47, -23) #X6:2};
//   &n6 @WIRE(mode="straight") {#X6:1 (23, -23) (23, -30) (82, -30) (82, -23) #X7:2};
//   %ground0 = $GROUND @ATTACH &g => @PLACE(35, -7);
//   &g @WIRE(mode="straight") {#X2:3 %ground0:p};
//   %ground1 = $GROUND @ATTACH &g => @PLACE(70, -7);
//   &g @WIRE(mode="straight") {#X3:3 %ground1:p};
//   %ground2 = $GROUND @ATTACH &g => @PLACE(105, -7);
//   &g @WIRE(mode="straight") {#X4:3 %ground2:p};
//   %ground3 = $GROUND @ATTACH &g => @PLACE(0, -30);
//   &g @WIRE(mode="straight") {#X5:3 %ground3:p};
//   %ground4 = $GROUND @ATTACH &g => @PLACE(35, -30);
//   &g @WIRE(mode="straight") {#X6:3 %ground4:p};
//   %ground5 = $GROUND @ATTACH &g => @PLACE(70, -30);
//   &g @WIRE(mode="straight") {#X7:3 %ground5:p}
// }
ends TM_REF_REF_NOISE
