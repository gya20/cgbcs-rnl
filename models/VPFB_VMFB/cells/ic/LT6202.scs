simulator lang=spectre
// @RNL(type="header") { @VERSION("0.3"); @USE-PACKAGE(name="cgbcs-vpfb-vmfb", version="1.0", path="../../symbols.rnl") }
subckt L2_TM_REF_LT6202 (p n o bias g)
parameters a0=100k fu=99.9M ro=3.98 fo=2036 f2=1.481M ew=1.9n vos=0
Xamp (p n z bias g) L3_TM_REF_AMP a0=a0 fu=fu ro=ro ew=ew vos=vos f2=f2
Rz (z o) resistor r=300 isnoisy=no
Cz (z o) capacitor c=1/(6.283185307*300*fo)
// @RNL {
//   #Xamp @PLACE(0, 0);
//   #Rz @PLACE(18, 0);
//   (18, 1.45) @TEXT("Rz  300", size=0.76, halign="middle");
//   #Cz @PLACE(18, 9);
//   (18, 10.45) @TEXT("Cz  C(eq)", size=0.76, halign="middle");
//   %port_p = $IO_PORT @ATTACH &p => @PLACE(-16,-2) => @ORIENT("R0");
//   &p @WIRE(mode="straight") {%port_p:p #Xamp:1};
//   %port_n = $IO_PORT @ATTACH &n => @PLACE(-16,2) => @ORIENT("R0");
//   &n @WIRE(mode="straight") {%port_n:p #Xamp:2};
//   %port_bias = $IO_PORT @ATTACH &bias => @PLACE(5,9) => @ORIENT("R180");
//   &bias @WIRE(mode="straight") {%port_bias:p (-2, 9) #Xamp:4};
//   %ground1 = $GROUND @ATTACH &g => @PLACE(-2,-9);
//   &g @WIRE(mode="straight") {#Xamp:5 %ground1:p};
//   %j2 = (11, 0);
//   $JUNCTION @ATTACH %j2;
//   %j3 = (25, 0);
//   $JUNCTION @ATTACH %j3;
//   &z @WIRE(mode="straight") {#Xamp:3 %j2 #Rz:1};
//   &z @WIRE(mode="straight") {%j2 (11, 9) #Cz:1};
//   %port_o = $IO_PORT @ATTACH &o => @PLACE(31,0) => @ORIENT("R180");
//   &o @WIRE(mode="straight") {#Rz:2 %j3 %port_o:p};
//   &o @WIRE(mode="straight") {#Cz:2 (25, 9) %j3};
//   %port_g = $IO_PORT @ATTACH &g => @PLACE(-16,-11) => @ORIENT("R0");
//   %common = $GROUND @ATTACH &g => @PLACE(-13,-13);
//   &g @WIRE(mode="straight") {%port_g:p (-13, -11) %common:p}
// }
ends L2_TM_REF_LT6202
