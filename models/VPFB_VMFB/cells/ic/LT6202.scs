simulator lang=spectre
// @RNL(type="header") { @VERSION("0.3"); @USE-PACKAGE(name="cgbcs-vpfb-vmfb", version="1.0", path="../../symbols.rnl") }

subckt L2_TM_REF_LT6202 (p n o bias g)
parameters a0=100k fu=99.9M ro=4.2263 fo=1023.48 f2=2.6741M rz=557.893 ew=1.9n vos=0
Xn (pn p g) L4_TM_COMMON_NOISE ew=ew
Eos (pi pn bias g) vcvs gain=vos
Gerr (g x pi n) vccs gm=a0/1M
Rd (x g) resistor r=1M isnoisy=no
Cd (x g) capacitor c=a0/(6.283185307*1M*fu)
E1 (u g x g) vcvs gain=1
R2 (u y) resistor r=1k isnoisy=no
C2 (y g) capacitor c=1/(6.283185307*1k*f2)
Ebuf (b g y g) vcvs gain=1
Ro (b z) resistor r=ro isnoisy=no
Rz (z o) resistor r=rz isnoisy=no
Cz (z o) capacitor c=1/(6.283185307*rz*fo)
// @RNL {
//   #Xn @PLACE(0, 0);
//   #Eos @PLACE(16, 0) => @ORIENT("R270");
//   (18.4, 1.4) @TEXT("Eos  vos", size=0.76, halign="start");
//   #Gerr @PLACE(36, -4) => @ORIENT("MX");
//   (38.4, -2.6) @TEXT("Gerr  gm", size=0.76, halign="start");
//   #Rd @PLACE(47, -4) => @ORIENT("R270");
//   (48.5, -4) @TEXT("Rd  1M", size=0.76, halign="start");
//   #Cd @PLACE(57, -4) => @ORIENT("R270");
//   (58.5, -4) @TEXT("Cd  Cd", size=0.76, halign="start");
//   #E1 @PLACE(73, -4);
//   (75.4, -2.6) @TEXT("E1  1", size=0.76, halign="start");
//   #R2 @PLACE(84, 4);
//   (84, 5.45) @TEXT("R2  1k", size=0.76, halign="middle");
//   #C2 @PLACE(94, -4) => @ORIENT("R270");
//   (95.5, -4) @TEXT("C2  C2", size=0.76, halign="start");
//   #Ebuf @PLACE(110, -4);
//   (112.4, -2.6) @TEXT("Ebuf  1", size=0.76, halign="start");
//   #Ro @PLACE(122, 4);
//   (122, 5.45) @TEXT("Ro  ro", size=0.76, halign="middle");
//   #Rz @PLACE(141, 4);
//   (141, 5.45) @TEXT("Rz  rz", size=0.76, halign="middle");
//   #Cz @PLACE(141, 12);
//   (141, 13.45) @TEXT("Cz  C(eq)", size=0.76, halign="middle");
//   %port_p = $IO_PORT @ATTACH &p => @PLACE(-12,0) => @ORIENT("R0");
//   &p @WIRE(mode="straight") {%port_p:p #Xn:2};
//   &pn @WIRE(mode="straight") {#Xn:1 #Eos:2};
//   &pi @WIRE(mode="straight") {#Eos:1 (26, 0) (26, -5) #Gerr:3};
//   %port_n = $IO_PORT @ATTACH &n => @PLACE(19,-10) => @ORIENT("R0");
//   &n @WIRE(mode="straight") {%port_n:p (29, -10) (29, -3) #Gerr:4};
//   %ground1 = $GROUND @ATTACH &g => @PLACE(0,-7);
//   &g @WIRE(mode="straight") {#Xn:3 %ground1:p};
//   %ground2 = $GROUND @ATTACH &g => @PLACE(12,2);
//   &g @WIRE(mode="straight") {#Eos:4 (12, 4) %ground2:p};
//   %port_bias = $IO_PORT @ATTACH &bias => @PLACE(21,9) => @ORIENT("R180");
//   &bias @WIRE(mode="straight") {%port_bias:p (17, 9) #Eos:3};
//   %ground3 = $GROUND @ATTACH &g => @PLACE(36,-10);
//   &g @WIRE(mode="straight") {#Gerr:1 %ground3:p};
//   %j4 = (47, 4);
//   $JUNCTION @ATTACH %j4;
//   %j5 = (57, 4);
//   $JUNCTION @ATTACH %j5;
//   &x @WIRE(mode="straight") {#Gerr:2 (36, 4) %j4 %j5};
//   &x @WIRE(mode="straight") {%j4 #Rd:1};
//   &x @WIRE(mode="straight") {%j5 #Cd:1};
//   %ground6 = $GROUND @ATTACH &g => @PLACE(47,-10);
//   &g @WIRE(mode="straight") {#Rd:2 %ground6:p};
//   %ground7 = $GROUND @ATTACH &g => @PLACE(57,-10);
//   &g @WIRE(mode="straight") {#Cd:2 %ground7:p};
//   &x @WIRE(mode="straight") {%j5 (66, 4) (66, -3) #E1:3};
//   %ground8 = $GROUND @ATTACH &g => @PLACE(73,-10);
//   &g @WIRE(mode="straight") {#E1:2 %ground8:p};
//   %ground9 = $GROUND @ATTACH &g => @PLACE(67,-8);
//   &g @WIRE(mode="straight") {#E1:4 (67, -5) %ground9:p};
//   &u @WIRE(mode="straight") {#E1:1 (73, 4) #R2:1};
//   %j10 = (94, 4);
//   $JUNCTION @ATTACH %j10;
//   &y @WIRE(mode="straight") {#R2:2 %j10};
//   &y @WIRE(mode="straight") {%j10 #C2:1};
//   %ground11 = $GROUND @ATTACH &g => @PLACE(94,-10);
//   &g @WIRE(mode="straight") {#C2:2 %ground11:p};
//   &y @WIRE(mode="straight") {%j10 (102, 4) (102, -3) #Ebuf:3};
//   %ground12 = $GROUND @ATTACH &g => @PLACE(110,-10);
//   &g @WIRE(mode="straight") {#Ebuf:2 %ground12:p};
//   %ground13 = $GROUND @ATTACH &g => @PLACE(104,-8);
//   &g @WIRE(mode="straight") {#Ebuf:4 (104, -5) %ground13:p};
//   &b @WIRE(mode="straight") {#Ebuf:1 (110, 4) #Ro:1};
//   %j14 = (132, 4);
//   $JUNCTION @ATTACH %j14;
//   %j15 = (151, 4);
//   $JUNCTION @ATTACH %j15;
//   &z @WIRE(mode="straight") {#Ro:2 %j14 #Rz:1};
//   &z @WIRE(mode="straight") {%j14 (132, 12) #Cz:1};
//   %port_o = $IO_PORT @ATTACH &o => @PLACE(158,4) => @ORIENT("R180");
//   &o @WIRE(mode="straight") {#Rz:2 %j15 %port_o:p};
//   &o @WIRE(mode="straight") {#Cz:2 (151, 12) %j15};
//   %port_g = $IO_PORT @ATTACH &g => @PLACE(-14,-12) => @ORIENT("R0");
//   %common = $GROUND @ATTACH &g => @PLACE(-11,-14);
//   &g @WIRE(mode="straight") {%port_g:p (-11, -12) %common:p}
// }
ends L2_TM_REF_LT6202
