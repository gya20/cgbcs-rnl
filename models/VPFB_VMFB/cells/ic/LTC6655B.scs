simulator lang=spectre
// @RNL(type="header") { @VERSION("0.3"); @USE-PACKAGE(name="cgbcs-vpfb-vmfb", version="1.0", path="../../symbols.rnl") }
subckt TM_REF_LTC6655B (vin bias ref g)
parameters vnom=2.048 errppm=0 ew=39n fc=1 ro=10m
Eref (b g bias g) vcvs gain=vnom*(1+errppm*1u)
Xlf (bl b g) TM_REF_REF_NOISE en=ew fc=fc
Xn (bn bl g) TM_REF_NOISE ew=ew
Ro (bn ref) resistor r=ro isnoisy=no
// @RNL {
//   #Eref @PLACE(0, 0);
//   (0, -4.7) @TEXT("gain=vnom*(1+errppm*1u)", size=0.68, halign="middle");
//   #Xlf @PLACE(35, 0);
//   #Xn @PLACE(70, 0);
//   #Ro @PLACE(105, 0);
//   (105, -3.7) @TEXT("r=ro", size=0.68, halign="middle");
//   %io_vin = $IO_PORT @ATTACH &vin => @PLACE(-16, -22);
//   %io_bias = $IO_PORT @ATTACH &bias => @PLACE(-10, 1) => @ORIENT("R0");
//   &bias @WIRE(mode="straight") {%io_bias:p #Eref:3};
//   %io_ref = $IO_PORT @ATTACH &ref => @PLACE(114, 0) => @ORIENT("R180");
//   &ref @WIRE(mode="straight") {%io_ref:p #Ro:2};
//   %io_g = $IO_PORT @ATTACH &g => @PLACE(0, -9) => @ORIENT("R90");
//   &g @WIRE(mode="straight") {%io_g:p #Eref:2};
//   &b @WIRE(mode="straight") {#Eref:1 (0, 7) (47, 7) (47, 0) #Xlf:2};
//   &bl @WIRE(mode="straight") {#Xlf:1 (23, 0) (23, -6) (82, -6) (82, 0) #Xn:2};
//   &bn @WIRE(mode="straight") {#Xn:1 (58, 0) (58, 7) (100, 7) (100, 0) #Ro:1};
//   %ground0 = $GROUND @ATTACH &g => @PLACE(-6, -1);
//   &g @WIRE(mode="straight") {#Eref:4 %ground0:p};
//   %ground1 = $GROUND @ATTACH &g => @PLACE(35, -7);
//   &g @WIRE(mode="straight") {#Xlf:3 %ground1:p};
//   %ground2 = $GROUND @ATTACH &g => @PLACE(70, -7);
//   &g @WIRE(mode="straight") {#Xn:3 %ground2:p}
// }
ends TM_REF_LTC6655B
