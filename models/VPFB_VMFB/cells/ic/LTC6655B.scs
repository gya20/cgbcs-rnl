simulator lang=spectre
// @RNL(type="header") { @VERSION("0.3"); @USE-PACKAGE(name="cgbcs-vpfb-vmfb", version="1.0", path="../../symbols.rnl") }
subckt L2_TM_REF_LTC6655B (vin bias ref g)
parameters vnom=2.048 errppm=0 ew=39n fc=1 ro=10m
Eref (b g bias g) vcvs gain=vnom*(1+errppm*1u)
Xlf (bl b g) L3_TM_REF_REF_NOISE en=ew fc=fc
Xn (bn bl g) L4_TM_REF_NOISE ew=ew
Ro (bn ref) resistor r=ro isnoisy=no
// @RNL {
//   #Eref @PLACE(0, 0);
//   (2.4, 1.4) @TEXT("Eref  vnom*(1+errppm*1u)", size=0.76, halign="start");
//   #Xlf @PLACE(16, 4);
//   #Xn @PLACE(32, 4);
//   #Ro @PLACE(47, 4);
//   (47, 5.45) @TEXT("Ro  ro", size=0.76, halign="middle");
//   %io_vin = $IO_PORT @ATTACH &vin => @PLACE(-16, -22);
//   %io_bias = $IO_PORT @ATTACH &bias => @PLACE(-10, 1) => @ORIENT("R0");
//   &bias @WIRE(mode="straight") {%io_bias:p #Eref:3};
//   %io_ref = $IO_PORT @ATTACH &ref => @PLACE(56, 4) => @ORIENT("R180");
//   &ref @WIRE(mode="straight") {%io_ref:p #Ro:2};
//   %io_g = $IO_PORT @ATTACH &g => @PLACE(0, -9) => @ORIENT("R90");
//   &g @WIRE(mode="straight") {%io_g:p #Eref:2};
//   &b @WIRE(mode="straight") {#Eref:1 (0, 5) (9, 5) (9, 4) #Xlf:2};
//   &bl @WIRE(mode="straight") {#Xlf:1 #Xn:2};
//   &bn @WIRE(mode="straight") {#Xn:1 #Ro:1};
//   %ground0 = $GROUND @ATTACH &g => @PLACE(-6, -1);
//   &g @WIRE(mode="straight") {#Eref:4 %ground0:p};
//   %ground1 = $GROUND @ATTACH &g => @PLACE(16, -2);
//   &g @WIRE(mode="straight") {#Xlf:3 %ground1:p};
//   %ground2 = $GROUND @ATTACH &g => @PLACE(32, -2);
//   &g @WIRE(mode="straight") {#Xn:3 %ground2:p}
// }
ends L2_TM_REF_LTC6655B
