simulator lang=spectre
// @RNL(type="header") { @VERSION("0.3"); @USE-PACKAGE(name="cgbcs-vpfb-vmfb", version="1.0", path="symbols.rnl") }
include "Shared/RES.scs"
include "Shared/CAP.scs"
include "cells/basic/NOISE_POLE.scs"
include "cells/basic/NOISE_DECADE.scs"
include "Shared/NOISE.scs"
include "cells/ic/LTC6655B.scs"
include "stages/input/REF_INPUT.scs"
include "cells/ic/ADA4522.scs"
include "cells/ic/LT6202.scs"
include "Shared/LINE.scs"
include "stages/REF_CH.scs"

subckt L0_TM_REF_REF (vin bias padp diep padm diem g)
parameters rop=4.2263 rom=13.3148 rzp=557.893 rzm=1305.851 fop=1023.48 fom=1004.94 f2p=2.6741M f2m=10G esrb=2m eslb=0.1n ceff=220u lb=2n
Xref (vin bias ref g) L1_TM_REF_REF_INPUT
Xp (trim_p bias padp diep g) L1_TM_REF_REF_CH rt=220 rofast=rop rz=rzp fo=fop f2=f2p esrb=esrb eslb=eslb ceff=ceff lb=lb
Xm (trim_m bias padm diem g) L1_TM_REF_REF_CH rt=10k rofast=rom rz=rzm fo=fom f2=f2m esrb=esrb eslb=eslb ceff=ceff lb=lb
R14 (ref trim_p) L5_TM_COMMON_RES r=20
R22 (ref trim_mid) L5_TM_COMMON_RES r=470
R25 (trim_mid trim_m) L5_TM_COMMON_RES r=10
// @RNL {
//   #Xref @PLACE(-45, 0);
//   #Xp @PLACE(35, 19);
//   #Xm @PLACE(35, -19);
//   #R14 @PLACE(-6, 19);
//   (-6, 20.45) @TEXT("R14  20", size=0.76, halign="middle");
//   #R22 @PLACE(-14, -19);
//   (-14, -17.55) @TEXT("R22  470", size=0.76, halign="middle");
//   #R25 @PLACE(0, -19);
//   (0, -17.55) @TEXT("R25  10", size=0.76, halign="middle");
//   (35, 29) @TEXT("VPFB  /  2.0 V", size=1.24, halign="middle", valign="middle");
//   (35, -9) @TEXT("VMFB  /  1.0 V", size=1.24, halign="middle", valign="middle");
//   %port_vin = $IO_PORT @ATTACH &vin => @PLACE(-62,0) => @ORIENT("R0");
//   &vin @WIRE(mode="straight") {%port_vin:p #Xref:1};
//   %port_bias = $IO_PORT @ATTACH &bias => @PLACE(-53,-7) => @ORIENT("R0");
//   &bias @WIRE(mode="straight") {%port_bias:p (-48, -7) #Xref:2};
//   &bias @WIRE(mode="straight") {#Xp:2 (30, 10)};
//   (32, 10) @TEXT("bias", size=0.84, halign="middle", valign="middle");
//   &bias @WIRE(mode="straight") {#Xm:2 (30, -28)};
//   (32, -28) @TEXT("bias", size=0.84, halign="middle", valign="middle");
//   %j1 = (-25, 0);
//   $JUNCTION @ATTACH %j1;
//   &ref @WIRE(mode="straight") {#Xref:3 %j1};
//   &ref @WIRE(mode="straight") {%j1 (-25, 19) #R14:1};
//   &ref @WIRE(mode="straight") {%j1 (-25, -19) #R22:1};
//   %j2 = (-42, -7);
//   $JUNCTION @ATTACH %j2;
//   %port_g = $IO_PORT @ATTACH &g => @PLACE(-36,-7) => @ORIENT("R180");
//   &g @WIRE(mode="straight") {#Xref:4 %j2 %port_g:p};
//   %return = $GROUND @ATTACH &g => @PLACE(-42,-9);
//   &g @WIRE(mode="straight") {%j2 %return:p};
//   %ground3 = $GROUND @ATTACH &g => @PLACE(40,10);
//   &g @WIRE(mode="straight") {#Xp:5 %ground3:p};
//   %ground4 = $GROUND @ATTACH &g => @PLACE(40,-28);
//   &g @WIRE(mode="straight") {#Xm:5 %ground4:p};
//   &trim_p @WIRE(mode="straight") {#R14:2 #Xp:1};
//   %port_padp = $IO_PORT @ATTACH &padp => @PLACE(57,21) => @ORIENT("R180");
//   &padp @WIRE(mode="straight") {%port_padp:p #Xp:3};
//   %port_diep = $IO_PORT @ATTACH &diep => @PLACE(57,17) => @ORIENT("R180");
//   &diep @WIRE(mode="straight") {%port_diep:p #Xp:4};
//   &trim_m @WIRE(mode="straight") {#R25:2 #Xm:1};
//   %port_padm = $IO_PORT @ATTACH &padm => @PLACE(57,-17) => @ORIENT("R180");
//   &padm @WIRE(mode="straight") {%port_padm:p #Xm:3};
//   %port_diem = $IO_PORT @ATTACH &diem => @PLACE(57,-21) => @ORIENT("R180");
//   &diem @WIRE(mode="straight") {%port_diem:p #Xm:4};
//   &trim_mid @WIRE(mode="straight") {#R22:2 #R25:1}
// }
ends L0_TM_REF_REF
