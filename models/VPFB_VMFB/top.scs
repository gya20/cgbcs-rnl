simulator lang=spectre
// @RNL(type="header") { @VERSION("0.3"); @USE-PACKAGE(name="cgbcs-vpfb-vmfb", version="1.0", path="symbols.rnl") }
include "cells/basic/NOISE_POLE.scs"
include "cells/basic/NOISE_DECADE.scs"
include "cells/basic/REF_NOISE.scs"
include "cells/basic/NOISE.scs"
include "cells/ic/LTC6655B.scs"
include "stages/input/REF_INPUT.scs"
include "stages/input/REF_SET.scs"
include "cells/basic/AMP.scs"
include "cells/ic/ADA4522.scs"
include "stages/driver/SERVO.scs"
include "cells/ic/LT6202.scs"
include "stages/driver/FAST.scs"
include "cells/basic/LINE.scs"
include "cells/basic/CAPBR.scs"
include "stages/output/REF_PATH.scs"
include "stages/REF_CH.scs"

subckt TM_REF_REF (vin bias padp diep padm diem g)
parameters rop=3.98 rom=11.396 ceff=220u lb=2n
Xref (vin bias ref g) TM_REF_REF_INPUT
Xp (ref bias padp diep g) TM_REF_REF_CH rt=240 rofast=rop ceff=ceff lb=lb
Xm (ref bias padm diem g) TM_REF_REF_CH rt=10480 rofast=rom fo=4482 f2=10G ceff=ceff lb=lb
// @RNL {
//   #Xref @PLACE(0, 0);
//   #Xp @PLACE(35, 19);
//   #Xm @PLACE(35, -19);
//   (35, 30) @TEXT("VPFB  /  2.0 V", size=1.24, halign="middle", valign="middle");
//   (35, -8) @TEXT("VMFB  /  1.0 V", size=1.24, halign="middle", valign="middle");
//   %port_vin = $IO_PORT @ATTACH &vin => @PLACE(-17,0) => @ORIENT("R0");
//   &vin @WIRE(mode="straight") {%port_vin:p #Xref:1};
//   %port_bias = $IO_PORT @ATTACH &bias => @PLACE(-8,-7) => @ORIENT("R0");
//   &bias @WIRE(mode="straight") {%port_bias:p (-3, -7) #Xref:2};
//   &bias @WIRE(mode="straight") {#Xp:2 (29, 10)};
//   (29, 10.8) @TEXT("bias", size=0.75, halign="middle", valign="middle");
//   &bias @WIRE(mode="straight") {#Xm:2 (29, -28)};
//   (29, -27.2) @TEXT("bias", size=0.75, halign="middle", valign="middle");
//   %j1 = (15, 0);
//   $JUNCTION @ATTACH %j1;
//   &ref @WIRE(mode="straight") {#Xref:3 %j1};
//   &ref @WIRE(mode="straight") {%j1 (15, 22) #Xp:1};
//   &ref @WIRE(mode="straight") {%j1 (15, -16) #Xm:1};
//   %j2 = (3, -7);
//   $JUNCTION @ATTACH %j2;
//   %port_g = $IO_PORT @ATTACH &g => @PLACE(9,-7) => @ORIENT("R180");
//   &g @WIRE(mode="straight") {#Xref:4 %j2 %port_g:p};
//   %return = $GROUND @ATTACH &g => @PLACE(3,-9);
//   &g @WIRE(mode="straight") {%j2 %return:p};
//   %ground3 = $GROUND @ATTACH &g => @PLACE(39,10);
//   &g @WIRE(mode="straight") {#Xp:5 %ground3:p};
//   %ground4 = $GROUND @ATTACH &g => @PLACE(39,-28);
//   &g @WIRE(mode="straight") {#Xm:5 %ground4:p};
//   %port_padp = $IO_PORT @ATTACH &padp => @PLACE(57,22) => @ORIENT("R180");
//   &padp @WIRE(mode="straight") {%port_padp:p #Xp:3};
//   %port_diep = $IO_PORT @ATTACH &diep => @PLACE(57,16) => @ORIENT("R180");
//   &diep @WIRE(mode="straight") {%port_diep:p #Xp:4};
//   %port_padm = $IO_PORT @ATTACH &padm => @PLACE(57,-16) => @ORIENT("R180");
//   &padm @WIRE(mode="straight") {%port_padm:p #Xm:3};
//   %port_diem = $IO_PORT @ATTACH &diem => @PLACE(57,-22) => @ORIENT("R180");
//   &diem @WIRE(mode="straight") {%port_diem:p #Xm:4}
// }
ends TM_REF_REF
